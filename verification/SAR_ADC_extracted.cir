* Extracted by KLayout with SG13G2 LVS runset on : 11/07/2026 05:27

.SUBCKT SAR_ADC gnd vref vdd clk_cmp vbias D1 D9 D0 clk_samp sign D4 D2 D5 D8
+ D3 D10 D7 D11 D6 Vinn Vinp
X$21 gnd clk_samp vdd Vinn \$211 bootstrap_switch$1
X$24 gnd clk_samp vdd Vinp \$212 bootstrap_switch
X$54 gnd vdd \$4 clk_cmp \$120 \$126 \$127 vbias dynamic_comparator_new
X$59 \$13 \$12 \$9 \$6 \$3 \$26 vref \$91 \$89 \$87 \$92 \$88 \$90 \$120 cdac$2
X$78 \$22 \$18 \$11 \$10 \$5 \$35 vref \$82 \$81 \$80 \$85 \$84 \$83 \$4 cdac
X$100 gnd \$17 D1 \$127 \$126 vdd \$23 \$20 \$14 clk_cmp \$98 \$49 \$58 D0
+ clk_samp sign D4 \$71 D9 D8 \$21 \$19 \$8 D5 \$99 \$45 \$60 D2 \$16 D3 \$15
+ D10 \$42 \$43 \$41 D7 D6 \$7 \$206 \$76 \$72 \$24 D11 sar_logic
X$112 \$7 \$8 \$14 \$15 \$16 \$23 gnd vref \$26 \$13 \$12 \$9 \$6 \$3 vdd \$71
+ \$72 \$42 \$98 \$99 \$41 \$92 \$88 \$90 \$91 \$89 \$87 switch_array_new$2
X$128 \$24 \$21 \$20 \$19 \$45 \$17 gnd vref \$35 \$22 \$18 \$11 \$10 \$5 vdd
+ \$58 \$206 \$43 \$49 \$60 \$76 \$85 \$84 \$83 \$82 \$81 \$80 switch_array_new
.ENDS SAR_ADC

.SUBCKT switch_array_new D5 D4 D3 D2 D1 D0 gnd Vref S5 S4 S3 S2 S1 S0 vdd D_MSB
+ D10 D9 D8 D7 D6 S_MSB S10 S9 S8 S7 S6
M$1 Vref D5 S5 gnd sg13_lv_nmos L=0.13u W=2u AS=0.68p AD=0.68p PS=4.68u PD=4.68u
M$2 Vref D4 S4 gnd sg13_lv_nmos L=0.13u W=2u AS=0.68p AD=0.68p PS=4.68u PD=4.68u
M$3 Vref D3 S3 gnd sg13_lv_nmos L=0.13u W=2u AS=0.68p AD=0.68p PS=4.68u PD=4.68u
M$4 Vref D2 S2 gnd sg13_lv_nmos L=0.13u W=2u AS=0.68p AD=0.68p PS=4.68u PD=4.68u
M$5 Vref D1 S1 gnd sg13_lv_nmos L=0.13u W=2u AS=0.68p AD=0.68p PS=4.68u PD=4.68u
M$6 Vref D0 S0 gnd sg13_lv_nmos L=0.13u W=2u AS=0.68p AD=0.68p PS=4.68u PD=4.68u
M$7 gnd \$110 S7 gnd sg13_lv_nmos L=0.13u W=2u AS=0.68p AD=0.68p PS=4.68u
+ PD=4.68u
M$8 gnd \$109 S8 gnd sg13_lv_nmos L=0.13u W=2u AS=0.68p AD=0.68p PS=4.68u
+ PD=4.68u
M$9 gnd \$108 S9 gnd sg13_lv_nmos L=0.13u W=2u AS=0.68p AD=0.68p PS=4.68u
+ PD=4.68u
M$10 gnd \$111 S6 gnd sg13_lv_nmos L=0.13u W=2u AS=0.68p AD=0.68p PS=4.68u
+ PD=4.68u
M$11 gnd \$25 S2 gnd sg13_lv_nmos L=0.13u W=2u AS=0.68p AD=0.68p PS=4.68u
+ PD=4.68u
M$12 gnd \$23 S4 gnd sg13_lv_nmos L=0.13u W=2u AS=0.68p AD=0.68p PS=4.68u
+ PD=4.68u
M$13 gnd \$21 S5 gnd sg13_lv_nmos L=0.13u W=2u AS=0.68p AD=0.68p PS=4.68u
+ PD=4.68u
M$14 gnd \$24 S3 gnd sg13_lv_nmos L=0.13u W=2u AS=0.68p AD=0.68p PS=4.68u
+ PD=4.68u
M$15 gnd \$106 S_MSB gnd sg13_lv_nmos L=0.13u W=2u AS=0.68p AD=0.68p PS=4.68u
+ PD=4.68u
M$16 gnd \$26 S1 gnd sg13_lv_nmos L=0.13u W=2u AS=0.68p AD=0.68p PS=4.68u
+ PD=4.68u
M$17 gnd \$107 S10 gnd sg13_lv_nmos L=0.13u W=2u AS=0.68p AD=0.68p PS=4.68u
+ PD=4.68u
M$18 gnd \$27 S0 gnd sg13_lv_nmos L=0.13u W=2u AS=0.68p AD=0.68p PS=4.68u
+ PD=4.68u
M$19 Vref D6 S6 gnd sg13_lv_nmos L=0.13u W=2u AS=0.68p AD=0.68p PS=4.68u
+ PD=4.68u
M$20 Vref D7 S7 gnd sg13_lv_nmos L=0.13u W=2u AS=0.68p AD=0.68p PS=4.68u
+ PD=4.68u
M$21 Vref D8 S8 gnd sg13_lv_nmos L=0.13u W=2u AS=0.68p AD=0.68p PS=4.68u
+ PD=4.68u
M$22 Vref D9 S9 gnd sg13_lv_nmos L=0.13u W=2u AS=0.68p AD=0.68p PS=4.68u
+ PD=4.68u
M$23 Vref D10 S10 gnd sg13_lv_nmos L=0.13u W=2u AS=0.68p AD=0.68p PS=4.68u
+ PD=4.68u
M$24 Vref D_MSB S_MSB gnd sg13_lv_nmos L=0.13u W=2u AS=0.68p AD=0.68p PS=4.68u
+ PD=4.68u
M$25 gnd D5 S5 vdd sg13_lv_pmos L=0.13u W=4u AS=1.36p AD=1.36p PS=8.68u PD=8.68u
M$26 gnd D4 S4 vdd sg13_lv_pmos L=0.13u W=4u AS=1.36p AD=1.36p PS=8.68u PD=8.68u
M$27 gnd D3 S3 vdd sg13_lv_pmos L=0.13u W=4u AS=1.36p AD=1.36p PS=8.68u PD=8.68u
M$28 gnd D2 S2 vdd sg13_lv_pmos L=0.13u W=4u AS=1.36p AD=1.36p PS=8.68u PD=8.68u
M$29 gnd D1 S1 vdd sg13_lv_pmos L=0.13u W=4u AS=1.36p AD=1.36p PS=8.68u PD=8.68u
M$30 gnd D0 S0 vdd sg13_lv_pmos L=0.13u W=4u AS=1.36p AD=1.36p PS=8.68u PD=8.68u
M$31 gnd D7 S7 vdd sg13_lv_pmos L=0.13u W=4u AS=1.36p AD=1.36p PS=8.68u PD=8.68u
M$32 gnd D8 S8 vdd sg13_lv_pmos L=0.13u W=4u AS=1.36p AD=1.36p PS=8.68u PD=8.68u
M$33 gnd D6 S6 vdd sg13_lv_pmos L=0.13u W=4u AS=1.36p AD=1.36p PS=8.68u PD=8.68u
M$34 gnd D9 S9 vdd sg13_lv_pmos L=0.13u W=4u AS=1.36p AD=1.36p PS=8.68u PD=8.68u
M$35 gnd D10 S10 vdd sg13_lv_pmos L=0.13u W=4u AS=1.36p AD=1.36p PS=8.68u
+ PD=8.68u
M$36 gnd D_MSB S_MSB vdd sg13_lv_pmos L=0.13u W=4u AS=1.36p AD=1.36p PS=8.68u
+ PD=8.68u
M$37 Vref \$21 S5 vdd sg13_lv_pmos L=0.13u W=4u AS=1.36p AD=1.36p PS=8.68u
+ PD=8.68u
M$38 Vref \$24 S3 vdd sg13_lv_pmos L=0.13u W=4u AS=1.36p AD=1.36p PS=8.68u
+ PD=8.68u
M$39 Vref \$26 S1 vdd sg13_lv_pmos L=0.13u W=4u AS=1.36p AD=1.36p PS=8.68u
+ PD=8.68u
M$40 Vref \$27 S0 vdd sg13_lv_pmos L=0.13u W=4u AS=1.36p AD=1.36p PS=8.68u
+ PD=8.68u
M$41 Vref \$110 S7 vdd sg13_lv_pmos L=0.13u W=4u AS=1.36p AD=1.36p PS=8.68u
+ PD=8.68u
M$42 Vref \$107 S10 vdd sg13_lv_pmos L=0.13u W=4u AS=1.36p AD=1.36p PS=8.68u
+ PD=8.68u
M$43 Vref \$106 S_MSB vdd sg13_lv_pmos L=0.13u W=4u AS=1.36p AD=1.36p PS=8.68u
+ PD=8.68u
M$44 Vref \$108 S9 vdd sg13_lv_pmos L=0.13u W=4u AS=1.36p AD=1.36p PS=8.68u
+ PD=8.68u
M$45 Vref \$109 S8 vdd sg13_lv_pmos L=0.13u W=4u AS=1.36p AD=1.36p PS=8.68u
+ PD=8.68u
M$46 Vref \$111 S6 vdd sg13_lv_pmos L=0.13u W=4u AS=1.36p AD=1.36p PS=8.68u
+ PD=8.68u
M$47 Vref \$25 S2 vdd sg13_lv_pmos L=0.13u W=4u AS=1.36p AD=1.36p PS=8.68u
+ PD=8.68u
M$48 Vref \$23 S4 vdd sg13_lv_pmos L=0.13u W=4u AS=1.36p AD=1.36p PS=8.68u
+ PD=8.68u
M$49 gnd D5 \$21 gnd sg13_lv_nmos L=0.13u W=0.4u AS=0.136p AD=0.136p PS=1.48u
+ PD=1.48u
M$50 gnd D4 \$23 gnd sg13_lv_nmos L=0.13u W=0.4u AS=0.136p AD=0.136p PS=1.48u
+ PD=1.48u
M$51 gnd D3 \$24 gnd sg13_lv_nmos L=0.13u W=0.4u AS=0.136p AD=0.136p PS=1.48u
+ PD=1.48u
M$52 gnd D2 \$25 gnd sg13_lv_nmos L=0.13u W=0.4u AS=0.136p AD=0.136p PS=1.48u
+ PD=1.48u
M$53 gnd D1 \$26 gnd sg13_lv_nmos L=0.13u W=0.4u AS=0.136p AD=0.136p PS=1.48u
+ PD=1.48u
M$54 gnd D0 \$27 gnd sg13_lv_nmos L=0.13u W=0.4u AS=0.136p AD=0.136p PS=1.48u
+ PD=1.48u
M$55 gnd D6 \$111 gnd sg13_lv_nmos L=0.13u W=0.4u AS=0.136p AD=0.136p PS=1.48u
+ PD=1.48u
M$56 gnd D9 \$108 gnd sg13_lv_nmos L=0.13u W=0.4u AS=0.136p AD=0.136p PS=1.48u
+ PD=1.48u
M$57 gnd D7 \$110 gnd sg13_lv_nmos L=0.13u W=0.4u AS=0.136p AD=0.136p PS=1.48u
+ PD=1.48u
M$58 gnd D_MSB \$106 gnd sg13_lv_nmos L=0.13u W=0.4u AS=0.136p AD=0.136p
+ PS=1.48u PD=1.48u
M$59 gnd D10 \$107 gnd sg13_lv_nmos L=0.13u W=0.4u AS=0.136p AD=0.136p PS=1.48u
+ PD=1.48u
M$60 gnd D8 \$109 gnd sg13_lv_nmos L=0.13u W=0.4u AS=0.136p AD=0.136p PS=1.48u
+ PD=1.48u
M$61 vdd D5 \$21 vdd sg13_lv_pmos L=0.13u W=0.8u AS=0.272p AD=0.272p PS=2.28u
+ PD=2.28u
M$62 vdd D4 \$23 vdd sg13_lv_pmos L=0.13u W=0.8u AS=0.272p AD=0.272p PS=2.28u
+ PD=2.28u
M$63 vdd D3 \$24 vdd sg13_lv_pmos L=0.13u W=0.8u AS=0.272p AD=0.272p PS=2.28u
+ PD=2.28u
M$64 vdd D2 \$25 vdd sg13_lv_pmos L=0.13u W=0.8u AS=0.272p AD=0.272p PS=2.28u
+ PD=2.28u
M$65 vdd D1 \$26 vdd sg13_lv_pmos L=0.13u W=0.8u AS=0.272p AD=0.272p PS=2.28u
+ PD=2.28u
M$66 vdd D0 \$27 vdd sg13_lv_pmos L=0.13u W=0.8u AS=0.272p AD=0.272p PS=2.28u
+ PD=2.28u
M$67 vdd D6 \$111 vdd sg13_lv_pmos L=0.13u W=0.8u AS=0.272p AD=0.272p PS=2.28u
+ PD=2.28u
M$68 vdd D7 \$110 vdd sg13_lv_pmos L=0.13u W=0.8u AS=0.272p AD=0.272p PS=2.28u
+ PD=2.28u
M$69 vdd D8 \$109 vdd sg13_lv_pmos L=0.13u W=0.8u AS=0.272p AD=0.272p PS=2.28u
+ PD=2.28u
M$70 vdd D9 \$108 vdd sg13_lv_pmos L=0.13u W=0.8u AS=0.272p AD=0.272p PS=2.28u
+ PD=2.28u
M$71 vdd D10 \$107 vdd sg13_lv_pmos L=0.13u W=0.8u AS=0.272p AD=0.272p PS=2.28u
+ PD=2.28u
M$72 vdd D_MSB \$106 vdd sg13_lv_pmos L=0.13u W=0.8u AS=0.272p AD=0.272p
+ PS=2.28u PD=2.28u
.ENDS switch_array_new

.SUBCKT dynamic_comparator_new gnd vdd Vplus clk Vminus out_plus out_minus vbias
R$1 \$4 gnd rppd w=2.5u l=18.02u ps=0.18u b=6 m=1
R$2 gnd \$6 rppd w=2.5u l=18.02u ps=0.18u b=6 m=1
M$3 \$22 Vminus \$4 vdd sg13_lv_pmos L=0.3u W=8u AS=2.72p AD=2.72p PS=16.68u
+ PD=16.68u
M$4 \$6 Vplus \$22 vdd sg13_lv_pmos L=0.3u W=8u AS=2.72p AD=2.72p PS=16.68u
+ PD=16.68u
M$5 vdd vbias \$22 vdd sg13_lv_pmos L=0.8u W=12u AS=4.08p AD=4.08p PS=24.68u
+ PD=24.68u
M$6 \$10 \$6 \$5 vdd sg13_lv_pmos L=0.3u W=32u AS=7.28p AD=7.28p PS=41.82u
+ PD=41.82u
M$10 \$10 \$4 \$13 vdd sg13_lv_pmos L=0.3u W=32u AS=7.28p AD=7.28p PS=41.82u
+ PD=41.82u
M$14 out_minus \$5 vdd vdd sg13_lv_pmos L=0.2u W=8u AS=2.72p AD=2.72p PS=16.68u
+ PD=16.68u
M$15 out_plus \$13 vdd vdd sg13_lv_pmos L=0.2u W=8u AS=2.72p AD=2.72p PS=16.68u
+ PD=16.68u
M$16 \$13 \$5 gnd gnd sg13_lv_nmos L=0.2u W=4u AS=1.36p AD=1.36p PS=8.68u
+ PD=8.68u
M$17 \$5 clk gnd gnd sg13_lv_nmos L=0.2u W=4u AS=1.36p AD=1.36p PS=8.68u
+ PD=8.68u
M$18 \$5 \$13 gnd gnd sg13_lv_nmos L=0.2u W=4u AS=1.36p AD=1.36p PS=8.68u
+ PD=8.68u
M$19 \$13 clk gnd gnd sg13_lv_nmos L=0.2u W=4u AS=1.36p AD=1.36p PS=8.68u
+ PD=8.68u
M$20 gnd \$13 out_plus gnd sg13_lv_nmos L=0.2u W=4u AS=1.36p AD=1.36p PS=8.68u
+ PD=8.68u
M$21 gnd \$5 out_minus gnd sg13_lv_nmos L=0.2u W=4u AS=1.36p AD=1.36p PS=8.68u
+ PD=8.68u
M$22 vdd vbias \$43 vdd sg13_lv_pmos L=0.3u W=18u AS=4.095p AD=4.095p PS=24.32u
+ PD=24.32u
M$26 \$43 clk \$10 vdd sg13_lv_pmos L=0.3u W=18u AS=4.095p AD=4.095p PS=24.32u
+ PD=24.32u
.ENDS dynamic_comparator_new

.SUBCKT bootstrap_switch gnd clk vdd vi vo
M$1 gnd \$3 \$29 gnd sg13_lv_nmos L=0.2u W=1.3u AS=0.442p AD=0.442p PS=3.28u
+ PD=3.28u
M$2 \$15 vdd \$23 gnd sg13_lv_nmos L=0.13u W=3u AS=1.02p AD=1.02p PS=6.68u
+ PD=6.68u
M$3 \$15 \$3 gnd gnd sg13_lv_nmos L=0.13u W=3u AS=1.02p AD=1.02p PS=6.68u
+ PD=6.68u
M$4 vi \$23 \$29 gnd sg13_lv_nmos L=0.25u W=3.5u AS=1.19p AD=1.19p PS=7.68u
+ PD=7.68u
M$5 vi \$3 vi gnd sg13_lv_nmos L=0.13u W=1.5u AS=0.51p AD=0.51p PS=3.68u
+ PD=3.68u
M$6 vo \$3 vo gnd sg13_lv_nmos L=0.13u W=1.5u AS=0.51p AD=0.51p PS=3.68u
+ PD=3.68u
M$7 vo \$25 vi gnd sg13_lv_nmos L=0.25u W=6u AS=2.04p AD=2.04p PS=12.68u
+ PD=12.68u
M$8 vdd \$18 \$19 gnd sg13_lv_nmos L=0.13u W=1.3u AS=0.442p AD=0.442p PS=3.28u
+ PD=3.28u
M$9 vdd \$19 \$22 gnd sg13_lv_nmos L=0.13u W=1.3u AS=0.442p AD=0.442p PS=3.28u
+ PD=3.28u
M$10 vdd \$19 \$18 gnd sg13_lv_nmos L=0.13u W=1.3u AS=0.442p AD=0.442p PS=3.28u
+ PD=3.28u
C$11 \$22 \$29 cap_cmim w=11.485u l=11.485u A=131.905225p P=45.94u m=1
C$12 \$19 \$3 cap_cmim w=4.665u l=6.99u A=32.60835p P=23.31u m=1
C$13 \$18 \$12 cap_cmim w=4.665u l=6.99u A=32.60835p P=23.31u m=1
M$14 \$23 \$35 vdd vdd sg13_lv_pmos L=0.13u W=0.5u AS=0.17p AD=0.17p PS=1.68u
+ PD=1.68u
M$15 \$22 \$50 \$25 \$22 sg13_lv_pmos L=0.13u W=0.5u AS=0.17p AD=0.17p PS=1.68u
+ PD=1.68u
M$16 \$36 \$3 gnd gnd sg13_lv_nmos L=0.13u W=0.5u AS=0.17p AD=0.17p PS=1.68u
+ PD=1.68u
M$17 \$25 vdd \$36 gnd sg13_lv_nmos L=0.13u W=0.5u AS=0.17p AD=0.17p PS=1.68u
+ PD=1.68u
M$18 vdd clk \$3 vdd sg13_lv_pmos L=0.13u W=0.8u AS=0.272p AD=0.272p PS=2.28u
+ PD=2.28u
M$19 vdd \$35 \$50 vdd sg13_lv_pmos L=0.13u W=0.8u AS=0.272p AD=0.272p PS=2.28u
+ PD=2.28u
M$20 vdd \$3 \$12 vdd sg13_lv_pmos L=0.13u W=0.8u AS=0.272p AD=0.272p PS=2.28u
+ PD=2.28u
M$21 gnd clk \$3 gnd sg13_lv_nmos L=0.13u W=0.4u AS=0.136p AD=0.136p PS=1.48u
+ PD=1.48u
M$22 gnd \$3 \$12 gnd sg13_lv_nmos L=0.13u W=0.4u AS=0.136p AD=0.136p PS=1.48u
+ PD=1.48u
M$23 gnd \$35 \$50 gnd sg13_lv_nmos L=0.13u W=0.4u AS=0.136p AD=0.136p PS=1.48u
+ PD=1.48u
.ENDS bootstrap_switch

.SUBCKT bootstrap_switch$1 gnd clk vdd vi vo
M$1 gnd \$3 \$29 gnd sg13_lv_nmos L=0.2u W=1.3u AS=0.442p AD=0.442p PS=3.28u
+ PD=3.28u
M$2 \$15 vdd \$23 gnd sg13_lv_nmos L=0.13u W=3u AS=1.02p AD=1.02p PS=6.68u
+ PD=6.68u
M$3 \$15 \$3 gnd gnd sg13_lv_nmos L=0.13u W=3u AS=1.02p AD=1.02p PS=6.68u
+ PD=6.68u
M$4 vi \$23 \$29 gnd sg13_lv_nmos L=0.25u W=3.5u AS=1.19p AD=1.19p PS=7.68u
+ PD=7.68u
M$5 vi \$3 vi gnd sg13_lv_nmos L=0.13u W=1.5u AS=0.51p AD=0.51p PS=3.68u
+ PD=3.68u
M$6 vo \$3 vo gnd sg13_lv_nmos L=0.13u W=1.5u AS=0.51p AD=0.51p PS=3.68u
+ PD=3.68u
M$7 vo \$25 vi gnd sg13_lv_nmos L=0.25u W=6u AS=2.04p AD=2.04p PS=12.68u
+ PD=12.68u
M$8 vdd \$18 \$19 gnd sg13_lv_nmos L=0.13u W=1.3u AS=0.442p AD=0.442p PS=3.28u
+ PD=3.28u
M$9 vdd \$19 \$22 gnd sg13_lv_nmos L=0.13u W=1.3u AS=0.442p AD=0.442p PS=3.28u
+ PD=3.28u
M$10 vdd \$19 \$18 gnd sg13_lv_nmos L=0.13u W=1.3u AS=0.442p AD=0.442p PS=3.28u
+ PD=3.28u
C$11 \$22 \$29 cap_cmim w=11.485u l=11.485u A=131.905225p P=45.94u m=1
C$12 \$19 \$3 cap_cmim w=4.665u l=6.99u A=32.60835p P=23.31u m=1
C$13 \$18 \$12 cap_cmim w=4.665u l=6.99u A=32.60835p P=23.31u m=1
M$14 \$23 \$35 vdd vdd sg13_lv_pmos L=0.13u W=0.5u AS=0.17p AD=0.17p PS=1.68u
+ PD=1.68u
M$15 \$22 \$50 \$25 \$22 sg13_lv_pmos L=0.13u W=0.5u AS=0.17p AD=0.17p PS=1.68u
+ PD=1.68u
M$16 \$36 \$3 gnd gnd sg13_lv_nmos L=0.13u W=0.5u AS=0.17p AD=0.17p PS=1.68u
+ PD=1.68u
M$17 \$25 vdd \$36 gnd sg13_lv_nmos L=0.13u W=0.5u AS=0.17p AD=0.17p PS=1.68u
+ PD=1.68u
M$18 vdd clk \$3 vdd sg13_lv_pmos L=0.13u W=0.8u AS=0.272p AD=0.272p PS=2.28u
+ PD=2.28u
M$19 vdd \$35 \$50 vdd sg13_lv_pmos L=0.13u W=0.8u AS=0.272p AD=0.272p PS=2.28u
+ PD=2.28u
M$20 vdd \$3 \$12 vdd sg13_lv_pmos L=0.13u W=0.8u AS=0.272p AD=0.272p PS=2.28u
+ PD=2.28u
M$21 gnd clk \$3 gnd sg13_lv_nmos L=0.13u W=0.4u AS=0.136p AD=0.136p PS=1.48u
+ PD=1.48u
M$22 gnd \$3 \$12 gnd sg13_lv_nmos L=0.13u W=0.4u AS=0.136p AD=0.136p PS=1.48u
+ PD=1.48u
M$23 gnd \$35 \$50 gnd sg13_lv_nmos L=0.13u W=0.4u AS=0.136p AD=0.136p PS=1.48u
+ PD=1.48u
.ENDS bootstrap_switch$1

.SUBCKT sar_logic VGND B[0] D[1] Om Op VPWR BN[0] B[3] BN[3] clk BN[8] B[8]
+ B[11] D[0] rst sign D[4] BN[11] D[9] D[8] B[4] B[2] BN[4] D[5] BN[7] B[1]
+ B[7] D[2] BN[1] D[3] BN[2] D[10] BN[9] B[9] BN[6] D[7] D[6] BN[5] B[10] B[6]
+ BN[10] B[5] D[11]
M$1 \$I4110 \$198 VGND VGND sg13_lv_nmos L=0.13u W=0.55u AS=0.187p AD=0.1045p
+ PS=1.78u PD=0.93u
M$2 VGND \$63 \$I4110 VGND sg13_lv_nmos L=0.13u W=0.55u AS=0.1045p AD=0.198p
+ PS=0.93u PD=1.27u
M$3 \$I4110 \$228 VGND VGND sg13_lv_nmos L=0.13u W=0.55u AS=0.198p AD=0.13395p
+ PS=1.27u PD=1.12u
M$4 VGND \$I4110 \$230 VGND sg13_lv_nmos L=0.13u W=0.74u AS=0.13395p AD=0.2516p
+ PS=1.12u PD=2.16u
M$5 \$I4110 \$198 \$I4112 VPWR sg13_lv_pmos L=0.13u W=1u AS=0.34p AD=0.19p
+ PS=2.68u PD=1.38u
M$6 \$I4112 \$63 \$I4111 VPWR sg13_lv_pmos L=0.13u W=1u AS=0.19p AD=0.1575p
+ PS=1.38u PD=1.315u
M$7 \$I4111 \$228 VPWR VPWR sg13_lv_pmos L=0.13u W=1u AS=0.1575p AD=0.3822p
+ PS=1.315u PD=1.84u
M$8 VPWR \$I4110 \$230 VPWR sg13_lv_pmos L=0.13u W=1.12u AS=0.3822p AD=0.3808p
+ PS=1.84u PD=2.92u
M$9 VGND \$90 \$I4113 VGND sg13_lv_nmos L=0.13u W=0.55u AS=0.187p AD=0.1045p
+ PS=1.78u PD=0.93u
M$10 \$I4113 \$64 VGND VGND sg13_lv_nmos L=0.13u W=0.55u AS=0.1045p AD=0.1469p
+ PS=0.93u PD=1.155u
M$11 VGND \$I4113 \$94 VGND sg13_lv_nmos L=0.13u W=0.74u AS=0.1469p AD=0.2516p
+ PS=1.155u PD=2.16u
M$12 \$I4113 \$90 \$I4114 VPWR sg13_lv_pmos L=0.13u W=0.84u AS=0.2856p
+ AD=0.1596p PS=2.36u PD=1.22u
M$13 VPWR \$64 \$I4114 VPWR sg13_lv_pmos L=0.13u W=0.84u AS=0.2226p AD=0.1596p
+ PS=1.535u PD=1.22u
M$14 VPWR \$I4113 \$94 VPWR sg13_lv_pmos L=0.13u W=1.12u AS=0.2226p AD=0.3976p
+ PS=1.535u PD=2.95u
M$15 VGND \$195 \$I4115 VGND sg13_lv_nmos L=0.13u W=0.55u AS=0.187p AD=0.1045p
+ PS=1.78u PD=0.93u
M$16 \$I4115 \$43 VGND VGND sg13_lv_nmos L=0.13u W=0.55u AS=0.1045p AD=0.1469p
+ PS=0.93u PD=1.155u
M$17 VGND \$I4115 \$228 VGND sg13_lv_nmos L=0.13u W=0.74u AS=0.1469p AD=0.2516p
+ PS=1.155u PD=2.16u
M$18 \$I4115 \$195 \$I4116 VPWR sg13_lv_pmos L=0.13u W=0.84u AS=0.2856p
+ AD=0.1596p PS=2.36u PD=1.22u
M$19 VPWR \$43 \$I4116 VPWR sg13_lv_pmos L=0.13u W=0.84u AS=0.2226p AD=0.1596p
+ PS=1.535u PD=1.22u
M$20 VPWR \$I4115 \$228 VPWR sg13_lv_pmos L=0.13u W=1.12u AS=0.2226p AD=0.3976p
+ PS=1.535u PD=2.95u
M$21 VGND \$18 \$431 VGND sg13_lv_nmos L=0.13u W=1.48u AS=0.3922p AD=0.2812p
+ PS=3.28u PD=2.24u
M$23 VGND \$317 \$431 VGND sg13_lv_nmos L=0.13u W=1.48u AS=0.2812p AD=0.3922p
+ PS=2.24u PD=3.28u
M$25 \$I4117 \$18 VPWR VPWR sg13_lv_pmos L=0.13u W=2.24u AS=0.616p AD=0.4256p
+ PS=4.46u PD=3u
M$27 \$I4117 \$317 \$431 VPWR sg13_lv_pmos L=0.13u W=2.24u AS=0.4256p
+ AD=0.5936p PS=3u PD=4.42u
M$29 VGND \$43 \$136 VGND sg13_lv_nmos L=0.13u W=1.48u AS=0.3922p AD=0.2812p
+ PS=3.28u PD=2.24u
M$31 VGND \$195 \$136 VGND sg13_lv_nmos L=0.13u W=1.48u AS=0.2812p AD=0.3922p
+ PS=2.24u PD=3.28u
M$33 \$I4118 \$43 VPWR VPWR sg13_lv_pmos L=0.13u W=2.24u AS=0.616p AD=0.4256p
+ PS=4.46u PD=3u
M$35 \$I4118 \$195 \$136 VPWR sg13_lv_pmos L=0.13u W=2.24u AS=0.4256p
+ AD=0.5936p PS=3u PD=4.42u
M$37 VGND \$I4120 \$I4119 VGND sg13_lv_nmos L=0.5u W=0.42u AS=0.1426p
+ AD=0.1428p PS=1.16u PD=1.52u
M$38 VGND \$I4119 \$84 VGND sg13_lv_nmos L=0.13u W=0.74u AS=0.1426p AD=0.2516p
+ PS=1.16u PD=2.16u
M$39 \$I4121 \$18 VGND VGND sg13_lv_nmos L=0.13u W=0.42u AS=0.1428p AD=0.0798p
+ PS=1.52u PD=0.8u
M$40 VGND \$I4121 \$I4120 VGND sg13_lv_nmos L=0.5u W=0.42u AS=0.0798p
+ AD=0.1428p PS=0.8u PD=1.52u
M$41 \$I4119 \$I4120 VPWR VPWR sg13_lv_pmos L=0.5u W=1u AS=0.34p AD=0.2254p
+ PS=2.68u PD=1.53u
M$42 VPWR \$I4119 \$84 VPWR sg13_lv_pmos L=0.13u W=1.12u AS=0.2254p AD=0.4256p
+ PS=1.53u PD=3u
M$43 VPWR \$18 \$I4121 VPWR sg13_lv_pmos L=0.13u W=0.42u AS=0.1523p AD=0.1428p
+ PS=1.38u PD=1.52u
M$44 VPWR \$I4121 \$I4120 VPWR sg13_lv_pmos L=0.5u W=1u AS=0.1523p AD=0.34p
+ PS=1.38u PD=2.68u
M$45 VGND \$I4123 \$I4122 VGND sg13_lv_nmos L=0.5u W=0.42u AS=0.1426p
+ AD=0.1428p PS=1.16u PD=1.52u
M$46 VGND \$I4122 \$51 VGND sg13_lv_nmos L=0.13u W=0.74u AS=0.1426p AD=0.2516p
+ PS=1.16u PD=2.16u
M$47 \$I4124 \$75 VGND VGND sg13_lv_nmos L=0.13u W=0.42u AS=0.1428p AD=0.0798p
+ PS=1.52u PD=0.8u
M$48 VGND \$I4124 \$I4123 VGND sg13_lv_nmos L=0.5u W=0.42u AS=0.0798p
+ AD=0.1428p PS=0.8u PD=1.52u
M$49 \$I4122 \$I4123 VPWR VPWR sg13_lv_pmos L=0.5u W=1u AS=0.34p AD=0.2254p
+ PS=2.68u PD=1.53u
M$50 VPWR \$I4122 \$51 VPWR sg13_lv_pmos L=0.13u W=1.12u AS=0.2254p AD=0.4256p
+ PS=1.53u PD=3u
M$51 VPWR \$75 \$I4124 VPWR sg13_lv_pmos L=0.13u W=0.42u AS=0.1523p AD=0.1428p
+ PS=1.38u PD=1.52u
M$52 VPWR \$I4124 \$I4123 VPWR sg13_lv_pmos L=0.5u W=1u AS=0.1523p AD=0.34p
+ PS=1.38u PD=2.68u
M$53 VGND \$I4126 \$I4125 VGND sg13_lv_nmos L=0.5u W=0.42u AS=0.1426p
+ AD=0.1428p PS=1.16u PD=1.52u
M$54 VGND \$I4125 \$114 VGND sg13_lv_nmos L=0.13u W=0.74u AS=0.1426p AD=0.2516p
+ PS=1.16u PD=2.16u
M$55 \$I4127 \$34 VGND VGND sg13_lv_nmos L=0.13u W=0.42u AS=0.1428p AD=0.0798p
+ PS=1.52u PD=0.8u
M$56 VGND \$I4127 \$I4126 VGND sg13_lv_nmos L=0.5u W=0.42u AS=0.0798p
+ AD=0.1428p PS=0.8u PD=1.52u
M$57 \$I4125 \$I4126 VPWR VPWR sg13_lv_pmos L=0.5u W=1u AS=0.34p AD=0.2254p
+ PS=2.68u PD=1.53u
M$58 VPWR \$I4125 \$114 VPWR sg13_lv_pmos L=0.13u W=1.12u AS=0.2254p AD=0.4256p
+ PS=1.53u PD=3u
M$59 VPWR \$34 \$I4127 VPWR sg13_lv_pmos L=0.13u W=0.42u AS=0.1523p AD=0.1428p
+ PS=1.38u PD=1.52u
M$60 VPWR \$I4127 \$I4126 VPWR sg13_lv_pmos L=0.5u W=1u AS=0.1523p AD=0.34p
+ PS=1.38u PD=2.68u
M$61 VGND \$I4129 \$I4128 VGND sg13_lv_nmos L=0.5u W=0.42u AS=0.1426p
+ AD=0.1428p PS=1.16u PD=1.52u
M$62 VGND \$I4128 \$265 VGND sg13_lv_nmos L=0.13u W=0.74u AS=0.1426p AD=0.2516p
+ PS=1.16u PD=2.16u
M$63 \$I4130 \$87 VGND VGND sg13_lv_nmos L=0.13u W=0.42u AS=0.1428p AD=0.0798p
+ PS=1.52u PD=0.8u
M$64 VGND \$I4130 \$I4129 VGND sg13_lv_nmos L=0.5u W=0.42u AS=0.0798p
+ AD=0.1428p PS=0.8u PD=1.52u
M$65 \$I4128 \$I4129 VPWR VPWR sg13_lv_pmos L=0.5u W=1u AS=0.34p AD=0.2254p
+ PS=2.68u PD=1.53u
M$66 VPWR \$I4128 \$265 VPWR sg13_lv_pmos L=0.13u W=1.12u AS=0.2254p AD=0.4256p
+ PS=1.53u PD=3u
M$67 VPWR \$87 \$I4130 VPWR sg13_lv_pmos L=0.13u W=0.42u AS=0.1523p AD=0.1428p
+ PS=1.38u PD=1.52u
M$68 VPWR \$I4130 \$I4129 VPWR sg13_lv_pmos L=0.5u W=1u AS=0.1523p AD=0.34p
+ PS=1.38u PD=2.68u
M$69 VGND \$I4132 \$I4131 VGND sg13_lv_nmos L=0.5u W=0.42u AS=0.1426p
+ AD=0.1428p PS=1.16u PD=1.52u
M$70 VGND \$I4131 \$150 VGND sg13_lv_nmos L=0.13u W=0.74u AS=0.1426p AD=0.2516p
+ PS=1.16u PD=2.16u
M$71 \$I4133 \$81 VGND VGND sg13_lv_nmos L=0.13u W=0.42u AS=0.1428p AD=0.0798p
+ PS=1.52u PD=0.8u
M$72 VGND \$I4133 \$I4132 VGND sg13_lv_nmos L=0.5u W=0.42u AS=0.0798p
+ AD=0.1428p PS=0.8u PD=1.52u
M$73 \$I4131 \$I4132 VPWR VPWR sg13_lv_pmos L=0.5u W=1u AS=0.34p AD=0.2254p
+ PS=2.68u PD=1.53u
M$74 VPWR \$I4131 \$150 VPWR sg13_lv_pmos L=0.13u W=1.12u AS=0.2254p AD=0.4256p
+ PS=1.53u PD=3u
M$75 VPWR \$81 \$I4133 VPWR sg13_lv_pmos L=0.13u W=0.42u AS=0.1523p AD=0.1428p
+ PS=1.38u PD=1.52u
M$76 VPWR \$I4133 \$I4132 VPWR sg13_lv_pmos L=0.5u W=1u AS=0.1523p AD=0.34p
+ PS=1.38u PD=2.68u
M$77 VGND \$I4135 \$I4134 VGND sg13_lv_nmos L=0.5u W=0.42u AS=0.1426p
+ AD=0.1428p PS=1.16u PD=1.52u
M$78 VGND \$I4134 \$103 VGND sg13_lv_nmos L=0.13u W=0.74u AS=0.1426p AD=0.2516p
+ PS=1.16u PD=2.16u
M$79 \$I4136 \$19 VGND VGND sg13_lv_nmos L=0.13u W=0.42u AS=0.1428p AD=0.0798p
+ PS=1.52u PD=0.8u
M$80 VGND \$I4136 \$I4135 VGND sg13_lv_nmos L=0.5u W=0.42u AS=0.0798p
+ AD=0.1428p PS=0.8u PD=1.52u
M$81 \$I4134 \$I4135 VPWR VPWR sg13_lv_pmos L=0.5u W=1u AS=0.34p AD=0.2254p
+ PS=2.68u PD=1.53u
M$82 VPWR \$I4134 \$103 VPWR sg13_lv_pmos L=0.13u W=1.12u AS=0.2254p AD=0.4256p
+ PS=1.53u PD=3u
M$83 VPWR \$19 \$I4136 VPWR sg13_lv_pmos L=0.13u W=0.42u AS=0.1523p AD=0.1428p
+ PS=1.38u PD=1.52u
M$84 VPWR \$I4136 \$I4135 VPWR sg13_lv_pmos L=0.5u W=1u AS=0.1523p AD=0.34p
+ PS=1.38u PD=2.68u
M$85 VGND \$I4138 \$I4137 VGND sg13_lv_nmos L=0.5u W=0.42u AS=0.1426p
+ AD=0.1428p PS=1.16u PD=1.52u
M$86 VGND \$I4137 \$86 VGND sg13_lv_nmos L=0.13u W=0.74u AS=0.1426p AD=0.2516p
+ PS=1.16u PD=2.16u
M$87 \$I4139 \$152 VGND VGND sg13_lv_nmos L=0.13u W=0.42u AS=0.1428p AD=0.0798p
+ PS=1.52u PD=0.8u
M$88 VGND \$I4139 \$I4138 VGND sg13_lv_nmos L=0.5u W=0.42u AS=0.0798p
+ AD=0.1428p PS=0.8u PD=1.52u
M$89 \$I4137 \$I4138 VPWR VPWR sg13_lv_pmos L=0.5u W=1u AS=0.34p AD=0.2254p
+ PS=2.68u PD=1.53u
M$90 VPWR \$I4137 \$86 VPWR sg13_lv_pmos L=0.13u W=1.12u AS=0.2254p AD=0.4256p
+ PS=1.53u PD=3u
M$91 VPWR \$152 \$I4139 VPWR sg13_lv_pmos L=0.13u W=0.42u AS=0.1523p AD=0.1428p
+ PS=1.38u PD=1.52u
M$92 VPWR \$I4139 \$I4138 VPWR sg13_lv_pmos L=0.5u W=1u AS=0.1523p AD=0.34p
+ PS=1.38u PD=2.68u
M$93 VGND \$I4141 \$I4140 VGND sg13_lv_nmos L=0.5u W=0.42u AS=0.1426p
+ AD=0.1428p PS=1.16u PD=1.52u
M$94 VGND \$I4140 \$232 VGND sg13_lv_nmos L=0.13u W=0.74u AS=0.1426p AD=0.2516p
+ PS=1.16u PD=2.16u
M$95 \$I4142 \$165 VGND VGND sg13_lv_nmos L=0.13u W=0.42u AS=0.1428p AD=0.0798p
+ PS=1.52u PD=0.8u
M$96 VGND \$I4142 \$I4141 VGND sg13_lv_nmos L=0.5u W=0.42u AS=0.0798p
+ AD=0.1428p PS=0.8u PD=1.52u
M$97 \$I4140 \$I4141 VPWR VPWR sg13_lv_pmos L=0.5u W=1u AS=0.34p AD=0.2254p
+ PS=2.68u PD=1.53u
M$98 VPWR \$I4140 \$232 VPWR sg13_lv_pmos L=0.13u W=1.12u AS=0.2254p AD=0.4256p
+ PS=1.53u PD=3u
M$99 VPWR \$165 \$I4142 VPWR sg13_lv_pmos L=0.13u W=0.42u AS=0.1523p AD=0.1428p
+ PS=1.38u PD=1.52u
M$100 VPWR \$I4142 \$I4141 VPWR sg13_lv_pmos L=0.5u W=1u AS=0.1523p AD=0.34p
+ PS=1.38u PD=2.68u
M$101 VGND \$I4144 \$I4143 VGND sg13_lv_nmos L=0.5u W=0.42u AS=0.1426p
+ AD=0.1428p PS=1.16u PD=1.52u
M$102 VGND \$I4143 \$45 VGND sg13_lv_nmos L=0.13u W=0.74u AS=0.1426p AD=0.2516p
+ PS=1.16u PD=2.16u
M$103 \$I4145 \$90 VGND VGND sg13_lv_nmos L=0.13u W=0.42u AS=0.1428p AD=0.0798p
+ PS=1.52u PD=0.8u
M$104 VGND \$I4145 \$I4144 VGND sg13_lv_nmos L=0.5u W=0.42u AS=0.0798p
+ AD=0.1428p PS=0.8u PD=1.52u
M$105 \$I4143 \$I4144 VPWR VPWR sg13_lv_pmos L=0.5u W=1u AS=0.34p AD=0.2254p
+ PS=2.68u PD=1.53u
M$106 VPWR \$I4143 \$45 VPWR sg13_lv_pmos L=0.13u W=1.12u AS=0.2254p AD=0.4256p
+ PS=1.53u PD=3u
M$107 VPWR \$90 \$I4145 VPWR sg13_lv_pmos L=0.13u W=0.42u AS=0.1523p AD=0.1428p
+ PS=1.38u PD=1.52u
M$108 VPWR \$I4145 \$I4144 VPWR sg13_lv_pmos L=0.5u W=1u AS=0.1523p AD=0.34p
+ PS=1.38u PD=2.68u
M$109 VGND \$I4147 \$I4146 VGND sg13_lv_nmos L=0.5u W=0.42u AS=0.1426p
+ AD=0.1428p PS=1.16u PD=1.52u
M$110 VGND \$I4146 \$175 VGND sg13_lv_nmos L=0.13u W=0.74u AS=0.1426p
+ AD=0.2516p PS=1.16u PD=2.16u
M$111 \$I4148 \$35 VGND VGND sg13_lv_nmos L=0.13u W=0.42u AS=0.1428p AD=0.0798p
+ PS=1.52u PD=0.8u
M$112 VGND \$I4148 \$I4147 VGND sg13_lv_nmos L=0.5u W=0.42u AS=0.0798p
+ AD=0.1428p PS=0.8u PD=1.52u
M$113 \$I4146 \$I4147 VPWR VPWR sg13_lv_pmos L=0.5u W=1u AS=0.34p AD=0.2254p
+ PS=2.68u PD=1.53u
M$114 VPWR \$I4146 \$175 VPWR sg13_lv_pmos L=0.13u W=1.12u AS=0.2254p
+ AD=0.4256p PS=1.53u PD=3u
M$115 VPWR \$35 \$I4148 VPWR sg13_lv_pmos L=0.13u W=0.42u AS=0.1523p AD=0.1428p
+ PS=1.38u PD=1.52u
M$116 VPWR \$I4148 \$I4147 VPWR sg13_lv_pmos L=0.5u W=1u AS=0.1523p AD=0.34p
+ PS=1.38u PD=2.68u
M$117 VGND \$I4150 \$I4149 VGND sg13_lv_nmos L=0.5u W=0.42u AS=0.1426p
+ AD=0.1428p PS=1.16u PD=1.52u
M$118 VGND \$I4149 \$288 VGND sg13_lv_nmos L=0.13u W=0.74u AS=0.1426p
+ AD=0.2516p PS=1.16u PD=2.16u
M$119 \$I4151 \$286 VGND VGND sg13_lv_nmos L=0.13u W=0.42u AS=0.1428p
+ AD=0.0798p PS=1.52u PD=0.8u
M$120 VGND \$I4151 \$I4150 VGND sg13_lv_nmos L=0.5u W=0.42u AS=0.0798p
+ AD=0.1428p PS=0.8u PD=1.52u
M$121 \$I4149 \$I4150 VPWR VPWR sg13_lv_pmos L=0.5u W=1u AS=0.34p AD=0.2254p
+ PS=2.68u PD=1.53u
M$122 VPWR \$I4149 \$288 VPWR sg13_lv_pmos L=0.13u W=1.12u AS=0.2254p
+ AD=0.4256p PS=1.53u PD=3u
M$123 VPWR \$286 \$I4151 VPWR sg13_lv_pmos L=0.13u W=0.42u AS=0.1523p
+ AD=0.1428p PS=1.38u PD=1.52u
M$124 VPWR \$I4151 \$I4150 VPWR sg13_lv_pmos L=0.5u W=1u AS=0.1523p AD=0.34p
+ PS=1.38u PD=2.68u
M$125 VGND \$I4153 \$I4152 VGND sg13_lv_nmos L=0.5u W=0.42u AS=0.1426p
+ AD=0.1428p PS=1.16u PD=1.52u
M$126 VGND \$I4152 \$253 VGND sg13_lv_nmos L=0.13u W=0.74u AS=0.1426p
+ AD=0.2516p PS=1.16u PD=2.16u
M$127 \$I4154 \$76 VGND VGND sg13_lv_nmos L=0.13u W=0.42u AS=0.1428p AD=0.0798p
+ PS=1.52u PD=0.8u
M$128 VGND \$I4154 \$I4153 VGND sg13_lv_nmos L=0.5u W=0.42u AS=0.0798p
+ AD=0.1428p PS=0.8u PD=1.52u
M$129 \$I4152 \$I4153 VPWR VPWR sg13_lv_pmos L=0.5u W=1u AS=0.34p AD=0.2254p
+ PS=2.68u PD=1.53u
M$130 VPWR \$I4152 \$253 VPWR sg13_lv_pmos L=0.13u W=1.12u AS=0.2254p
+ AD=0.4256p PS=1.53u PD=3u
M$131 VPWR \$76 \$I4154 VPWR sg13_lv_pmos L=0.13u W=0.42u AS=0.1523p AD=0.1428p
+ PS=1.38u PD=1.52u
M$132 VPWR \$I4154 \$I4153 VPWR sg13_lv_pmos L=0.5u W=1u AS=0.1523p AD=0.34p
+ PS=1.38u PD=2.68u
M$133 VGND \$I4156 \$I4155 VGND sg13_lv_nmos L=0.5u W=0.42u AS=0.1426p
+ AD=0.1428p PS=1.16u PD=1.52u
M$134 VGND \$I4155 \$317 VGND sg13_lv_nmos L=0.13u W=0.74u AS=0.1426p
+ AD=0.2516p PS=1.16u PD=2.16u
M$135 \$I4157 \$165 VGND VGND sg13_lv_nmos L=0.13u W=0.42u AS=0.1428p
+ AD=0.0798p PS=1.52u PD=0.8u
M$136 VGND \$I4157 \$I4156 VGND sg13_lv_nmos L=0.5u W=0.42u AS=0.0798p
+ AD=0.1428p PS=0.8u PD=1.52u
M$137 \$I4155 \$I4156 VPWR VPWR sg13_lv_pmos L=0.5u W=1u AS=0.34p AD=0.2254p
+ PS=2.68u PD=1.53u
M$138 VPWR \$I4155 \$317 VPWR sg13_lv_pmos L=0.13u W=1.12u AS=0.2254p
+ AD=0.4256p PS=1.53u PD=3u
M$139 VPWR \$165 \$I4157 VPWR sg13_lv_pmos L=0.13u W=0.42u AS=0.1523p
+ AD=0.1428p PS=1.38u PD=1.52u
M$140 VPWR \$I4157 \$I4156 VPWR sg13_lv_pmos L=0.5u W=1u AS=0.1523p AD=0.34p
+ PS=1.38u PD=2.68u
M$141 VGND \$I4159 \$I4158 VGND sg13_lv_nmos L=0.5u W=0.42u AS=0.1426p
+ AD=0.1428p PS=1.16u PD=1.52u
M$142 VGND \$I4158 \$140 VGND sg13_lv_nmos L=0.13u W=0.74u AS=0.1426p
+ AD=0.2516p PS=1.16u PD=2.16u
M$143 \$I4160 \$130 VGND VGND sg13_lv_nmos L=0.13u W=0.42u AS=0.1428p
+ AD=0.0798p PS=1.52u PD=0.8u
M$144 VGND \$I4160 \$I4159 VGND sg13_lv_nmos L=0.5u W=0.42u AS=0.0798p
+ AD=0.1428p PS=0.8u PD=1.52u
M$145 \$I4158 \$I4159 VPWR VPWR sg13_lv_pmos L=0.5u W=1u AS=0.34p AD=0.2254p
+ PS=2.68u PD=1.53u
M$146 VPWR \$I4158 \$140 VPWR sg13_lv_pmos L=0.13u W=1.12u AS=0.2254p
+ AD=0.4256p PS=1.53u PD=3u
M$147 VPWR \$130 \$I4160 VPWR sg13_lv_pmos L=0.13u W=0.42u AS=0.1523p
+ AD=0.1428p PS=1.38u PD=1.52u
M$148 VPWR \$I4160 \$I4159 VPWR sg13_lv_pmos L=0.5u W=1u AS=0.1523p AD=0.34p
+ PS=1.38u PD=2.68u
M$149 VGND \$I4162 \$I4161 VGND sg13_lv_nmos L=0.5u W=0.42u AS=0.1426p
+ AD=0.1428p PS=1.16u PD=1.52u
M$150 VGND \$I4161 \$344 VGND sg13_lv_nmos L=0.13u W=0.74u AS=0.1426p
+ AD=0.2516p PS=1.16u PD=2.16u
M$151 \$I4163 \$369 VGND VGND sg13_lv_nmos L=0.13u W=0.42u AS=0.1428p
+ AD=0.0798p PS=1.52u PD=0.8u
M$152 VGND \$I4163 \$I4162 VGND sg13_lv_nmos L=0.5u W=0.42u AS=0.0798p
+ AD=0.1428p PS=0.8u PD=1.52u
M$153 \$I4161 \$I4162 VPWR VPWR sg13_lv_pmos L=0.5u W=1u AS=0.34p AD=0.2254p
+ PS=2.68u PD=1.53u
M$154 VPWR \$I4161 \$344 VPWR sg13_lv_pmos L=0.13u W=1.12u AS=0.2254p
+ AD=0.4256p PS=1.53u PD=3u
M$155 VPWR \$369 \$I4163 VPWR sg13_lv_pmos L=0.13u W=0.42u AS=0.1523p
+ AD=0.1428p PS=1.38u PD=1.52u
M$156 VPWR \$I4163 \$I4162 VPWR sg13_lv_pmos L=0.5u W=1u AS=0.1523p AD=0.34p
+ PS=1.38u PD=2.68u
M$157 VGND \$I4165 \$I4164 VGND sg13_lv_nmos L=0.5u W=0.42u AS=0.1426p
+ AD=0.1428p PS=1.16u PD=1.52u
M$158 VGND \$I4164 \$342 VGND sg13_lv_nmos L=0.13u W=0.74u AS=0.1426p
+ AD=0.2516p PS=1.16u PD=2.16u
M$159 \$I4166 \$204 VGND VGND sg13_lv_nmos L=0.13u W=0.42u AS=0.1428p
+ AD=0.0798p PS=1.52u PD=0.8u
M$160 VGND \$I4166 \$I4165 VGND sg13_lv_nmos L=0.5u W=0.42u AS=0.0798p
+ AD=0.1428p PS=0.8u PD=1.52u
M$161 \$I4164 \$I4165 VPWR VPWR sg13_lv_pmos L=0.5u W=1u AS=0.34p AD=0.2254p
+ PS=2.68u PD=1.53u
M$162 VPWR \$I4164 \$342 VPWR sg13_lv_pmos L=0.13u W=1.12u AS=0.2254p
+ AD=0.4256p PS=1.53u PD=3u
M$163 VPWR \$204 \$I4166 VPWR sg13_lv_pmos L=0.13u W=0.42u AS=0.1523p
+ AD=0.1428p PS=1.38u PD=1.52u
M$164 VPWR \$I4166 \$I4165 VPWR sg13_lv_pmos L=0.5u W=1u AS=0.1523p AD=0.34p
+ PS=1.38u PD=2.68u
M$165 VGND \$I4168 \$I4167 VGND sg13_lv_nmos L=0.5u W=0.42u AS=0.1426p
+ AD=0.1428p PS=1.16u PD=1.52u
M$166 VGND \$I4167 \$458 VGND sg13_lv_nmos L=0.13u W=0.74u AS=0.1426p
+ AD=0.2516p PS=1.16u PD=2.16u
M$167 \$I4169 \$397 VGND VGND sg13_lv_nmos L=0.13u W=0.42u AS=0.1428p
+ AD=0.0798p PS=1.52u PD=0.8u
M$168 VGND \$I4169 \$I4168 VGND sg13_lv_nmos L=0.5u W=0.42u AS=0.0798p
+ AD=0.1428p PS=0.8u PD=1.52u
M$169 \$I4167 \$I4168 VPWR VPWR sg13_lv_pmos L=0.5u W=1u AS=0.34p AD=0.2254p
+ PS=2.68u PD=1.53u
M$170 VPWR \$I4167 \$458 VPWR sg13_lv_pmos L=0.13u W=1.12u AS=0.2254p
+ AD=0.4256p PS=1.53u PD=3u
M$171 VPWR \$397 \$I4169 VPWR sg13_lv_pmos L=0.13u W=0.42u AS=0.1523p
+ AD=0.1428p PS=1.38u PD=1.52u
M$172 VPWR \$I4169 \$I4168 VPWR sg13_lv_pmos L=0.5u W=1u AS=0.1523p AD=0.34p
+ PS=1.38u PD=2.68u
M$173 VGND \$I4171 \$I4170 VGND sg13_lv_nmos L=0.5u W=0.42u AS=0.1426p
+ AD=0.1428p PS=1.16u PD=1.52u
M$174 VGND \$I4170 \$302 VGND sg13_lv_nmos L=0.13u W=0.74u AS=0.1426p
+ AD=0.2516p PS=1.16u PD=2.16u
M$175 \$I4172 \$413 VGND VGND sg13_lv_nmos L=0.13u W=0.42u AS=0.1428p
+ AD=0.0798p PS=1.52u PD=0.8u
M$176 VGND \$I4172 \$I4171 VGND sg13_lv_nmos L=0.5u W=0.42u AS=0.0798p
+ AD=0.1428p PS=0.8u PD=1.52u
M$177 \$I4170 \$I4171 VPWR VPWR sg13_lv_pmos L=0.5u W=1u AS=0.34p AD=0.2254p
+ PS=2.68u PD=1.53u
M$178 VPWR \$I4170 \$302 VPWR sg13_lv_pmos L=0.13u W=1.12u AS=0.2254p
+ AD=0.4256p PS=1.53u PD=3u
M$179 VPWR \$413 \$I4172 VPWR sg13_lv_pmos L=0.13u W=0.42u AS=0.1523p
+ AD=0.1428p PS=1.38u PD=1.52u
M$180 VPWR \$I4172 \$I4171 VPWR sg13_lv_pmos L=0.5u W=1u AS=0.1523p AD=0.34p
+ PS=1.38u PD=2.68u
M$181 VGND \$I4174 \$I4173 VGND sg13_lv_nmos L=0.5u W=0.42u AS=0.1426p
+ AD=0.1428p PS=1.16u PD=1.52u
M$182 VGND \$I4173 \$396 VGND sg13_lv_nmos L=0.13u W=0.74u AS=0.1426p
+ AD=0.2516p PS=1.16u PD=2.16u
M$183 \$I4175 \$65 VGND VGND sg13_lv_nmos L=0.13u W=0.42u AS=0.1428p AD=0.0798p
+ PS=1.52u PD=0.8u
M$184 VGND \$I4175 \$I4174 VGND sg13_lv_nmos L=0.5u W=0.42u AS=0.0798p
+ AD=0.1428p PS=0.8u PD=1.52u
M$185 \$I4173 \$I4174 VPWR VPWR sg13_lv_pmos L=0.5u W=1u AS=0.34p AD=0.2254p
+ PS=2.68u PD=1.53u
M$186 VPWR \$I4173 \$396 VPWR sg13_lv_pmos L=0.13u W=1.12u AS=0.2254p
+ AD=0.4256p PS=1.53u PD=3u
M$187 VPWR \$65 \$I4175 VPWR sg13_lv_pmos L=0.13u W=0.42u AS=0.1523p AD=0.1428p
+ PS=1.38u PD=1.52u
M$188 VPWR \$I4175 \$I4174 VPWR sg13_lv_pmos L=0.5u W=1u AS=0.1523p AD=0.34p
+ PS=1.38u PD=2.68u
M$189 VGND \$I4177 \$I4176 VGND sg13_lv_nmos L=0.5u W=0.42u AS=0.1426p
+ AD=0.1428p PS=1.16u PD=1.52u
M$190 VGND \$I4176 \$504 VGND sg13_lv_nmos L=0.13u W=0.74u AS=0.1426p
+ AD=0.2516p PS=1.16u PD=2.16u
M$191 \$I4178 \$378 VGND VGND sg13_lv_nmos L=0.13u W=0.42u AS=0.1428p
+ AD=0.0798p PS=1.52u PD=0.8u
M$192 VGND \$I4178 \$I4177 VGND sg13_lv_nmos L=0.5u W=0.42u AS=0.0798p
+ AD=0.1428p PS=0.8u PD=1.52u
M$193 \$I4176 \$I4177 VPWR VPWR sg13_lv_pmos L=0.5u W=1u AS=0.34p AD=0.2254p
+ PS=2.68u PD=1.53u
M$194 VPWR \$I4176 \$504 VPWR sg13_lv_pmos L=0.13u W=1.12u AS=0.2254p
+ AD=0.4256p PS=1.53u PD=3u
M$195 VPWR \$378 \$I4178 VPWR sg13_lv_pmos L=0.13u W=0.42u AS=0.1523p
+ AD=0.1428p PS=1.38u PD=1.52u
M$196 VPWR \$I4178 \$I4177 VPWR sg13_lv_pmos L=0.5u W=1u AS=0.1523p AD=0.34p
+ PS=1.38u PD=2.68u
M$197 VGND \$I4180 \$I4179 VGND sg13_lv_nmos L=0.5u W=0.42u AS=0.1426p
+ AD=0.1428p PS=1.16u PD=1.52u
M$198 VGND \$I4179 \$427 VGND sg13_lv_nmos L=0.13u W=0.74u AS=0.1426p
+ AD=0.2516p PS=1.16u PD=2.16u
M$199 \$I4181 \$472 VGND VGND sg13_lv_nmos L=0.13u W=0.42u AS=0.1428p
+ AD=0.0798p PS=1.52u PD=0.8u
M$200 VGND \$I4181 \$I4180 VGND sg13_lv_nmos L=0.5u W=0.42u AS=0.0798p
+ AD=0.1428p PS=0.8u PD=1.52u
M$201 \$I4179 \$I4180 VPWR VPWR sg13_lv_pmos L=0.5u W=1u AS=0.34p AD=0.2254p
+ PS=2.68u PD=1.53u
M$202 VPWR \$I4179 \$427 VPWR sg13_lv_pmos L=0.13u W=1.12u AS=0.2254p
+ AD=0.4256p PS=1.53u PD=3u
M$203 VPWR \$472 \$I4181 VPWR sg13_lv_pmos L=0.13u W=0.42u AS=0.1523p
+ AD=0.1428p PS=1.38u PD=1.52u
M$204 VPWR \$I4181 \$I4180 VPWR sg13_lv_pmos L=0.5u W=1u AS=0.1523p AD=0.34p
+ PS=1.38u PD=2.68u
M$205 VGND \$I4183 \$I4182 VGND sg13_lv_nmos L=0.5u W=0.42u AS=0.1426p
+ AD=0.1428p PS=1.16u PD=1.52u
M$206 VGND \$I4182 \$513 VGND sg13_lv_nmos L=0.13u W=0.74u AS=0.1426p
+ AD=0.2516p PS=1.16u PD=2.16u
M$207 \$I4184 \$415 VGND VGND sg13_lv_nmos L=0.13u W=0.42u AS=0.1428p
+ AD=0.0798p PS=1.52u PD=0.8u
M$208 VGND \$I4184 \$I4183 VGND sg13_lv_nmos L=0.5u W=0.42u AS=0.0798p
+ AD=0.1428p PS=0.8u PD=1.52u
M$209 \$I4182 \$I4183 VPWR VPWR sg13_lv_pmos L=0.5u W=1u AS=0.34p AD=0.2254p
+ PS=2.68u PD=1.53u
M$210 VPWR \$I4182 \$513 VPWR sg13_lv_pmos L=0.13u W=1.12u AS=0.2254p
+ AD=0.4256p PS=1.53u PD=3u
M$211 VPWR \$415 \$I4184 VPWR sg13_lv_pmos L=0.13u W=0.42u AS=0.1523p
+ AD=0.1428p PS=1.38u PD=1.52u
M$212 VPWR \$I4184 \$I4183 VPWR sg13_lv_pmos L=0.5u W=1u AS=0.1523p AD=0.34p
+ PS=1.38u PD=2.68u
M$213 VGND \$I4186 \$I4185 VGND sg13_lv_nmos L=0.5u W=0.42u AS=0.1426p
+ AD=0.1428p PS=1.16u PD=1.52u
M$214 VGND \$I4185 \$422 VGND sg13_lv_nmos L=0.13u W=0.74u AS=0.1426p
+ AD=0.2516p PS=1.16u PD=2.16u
M$215 \$I4187 \$436 VGND VGND sg13_lv_nmos L=0.13u W=0.42u AS=0.1428p
+ AD=0.0798p PS=1.52u PD=0.8u
M$216 VGND \$I4187 \$I4186 VGND sg13_lv_nmos L=0.5u W=0.42u AS=0.0798p
+ AD=0.1428p PS=0.8u PD=1.52u
M$217 \$I4185 \$I4186 VPWR VPWR sg13_lv_pmos L=0.5u W=1u AS=0.34p AD=0.2254p
+ PS=2.68u PD=1.53u
M$218 VPWR \$I4185 \$422 VPWR sg13_lv_pmos L=0.13u W=1.12u AS=0.2254p
+ AD=0.4256p PS=1.53u PD=3u
M$219 VPWR \$436 \$I4187 VPWR sg13_lv_pmos L=0.13u W=0.42u AS=0.1523p
+ AD=0.1428p PS=1.38u PD=1.52u
M$220 VPWR \$I4187 \$I4186 VPWR sg13_lv_pmos L=0.5u W=1u AS=0.1523p AD=0.34p
+ PS=1.38u PD=2.68u
M$221 VGND \$I4189 \$I4188 VGND sg13_lv_nmos L=0.5u W=0.42u AS=0.1426p
+ AD=0.1428p PS=1.16u PD=1.52u
M$222 VGND \$I4188 \$545 VGND sg13_lv_nmos L=0.13u W=0.74u AS=0.1426p
+ AD=0.2516p PS=1.16u PD=2.16u
M$223 \$I4190 \$431 VGND VGND sg13_lv_nmos L=0.13u W=0.42u AS=0.1428p
+ AD=0.0798p PS=1.52u PD=0.8u
M$224 VGND \$I4190 \$I4189 VGND sg13_lv_nmos L=0.5u W=0.42u AS=0.0798p
+ AD=0.1428p PS=0.8u PD=1.52u
M$225 \$I4188 \$I4189 VPWR VPWR sg13_lv_pmos L=0.5u W=1u AS=0.34p AD=0.2254p
+ PS=2.68u PD=1.53u
M$226 VPWR \$I4188 \$545 VPWR sg13_lv_pmos L=0.13u W=1.12u AS=0.2254p
+ AD=0.4256p PS=1.53u PD=3u
M$227 VPWR \$431 \$I4190 VPWR sg13_lv_pmos L=0.13u W=0.42u AS=0.1523p
+ AD=0.1428p PS=1.38u PD=1.52u
M$228 VPWR \$I4190 \$I4189 VPWR sg13_lv_pmos L=0.5u W=1u AS=0.1523p AD=0.34p
+ PS=1.38u PD=2.68u
M$229 VGND \$I4192 \$I4191 VGND sg13_lv_nmos L=0.5u W=0.42u AS=0.1426p
+ AD=0.1428p PS=1.16u PD=1.52u
M$230 VGND \$I4191 \$678 VGND sg13_lv_nmos L=0.13u W=0.74u AS=0.1426p
+ AD=0.2516p PS=1.16u PD=2.16u
M$231 \$I4193 \$597 VGND VGND sg13_lv_nmos L=0.13u W=0.42u AS=0.1428p
+ AD=0.0798p PS=1.52u PD=0.8u
M$232 VGND \$I4193 \$I4192 VGND sg13_lv_nmos L=0.5u W=0.42u AS=0.0798p
+ AD=0.1428p PS=0.8u PD=1.52u
M$233 \$I4191 \$I4192 VPWR VPWR sg13_lv_pmos L=0.5u W=1u AS=0.34p AD=0.2254p
+ PS=2.68u PD=1.53u
M$234 VPWR \$I4191 \$678 VPWR sg13_lv_pmos L=0.13u W=1.12u AS=0.2254p
+ AD=0.4256p PS=1.53u PD=3u
M$235 VPWR \$597 \$I4193 VPWR sg13_lv_pmos L=0.13u W=0.42u AS=0.1523p
+ AD=0.1428p PS=1.38u PD=1.52u
M$236 VPWR \$I4193 \$I4192 VPWR sg13_lv_pmos L=0.5u W=1u AS=0.1523p AD=0.34p
+ PS=1.38u PD=2.68u
M$237 VGND \$I4195 \$I4194 VGND sg13_lv_nmos L=0.5u W=0.42u AS=0.1426p
+ AD=0.1428p PS=1.16u PD=1.52u
M$238 VGND \$I4194 \$488 VGND sg13_lv_nmos L=0.13u W=0.74u AS=0.1426p
+ AD=0.2516p PS=1.16u PD=2.16u
M$239 \$I4196 \$460 VGND VGND sg13_lv_nmos L=0.13u W=0.42u AS=0.1428p
+ AD=0.0798p PS=1.52u PD=0.8u
M$240 VGND \$I4196 \$I4195 VGND sg13_lv_nmos L=0.5u W=0.42u AS=0.0798p
+ AD=0.1428p PS=0.8u PD=1.52u
M$241 \$I4194 \$I4195 VPWR VPWR sg13_lv_pmos L=0.5u W=1u AS=0.34p AD=0.2254p
+ PS=2.68u PD=1.53u
M$242 VPWR \$I4194 \$488 VPWR sg13_lv_pmos L=0.13u W=1.12u AS=0.2254p
+ AD=0.4256p PS=1.53u PD=3u
M$243 VPWR \$460 \$I4196 VPWR sg13_lv_pmos L=0.13u W=0.42u AS=0.1523p
+ AD=0.1428p PS=1.38u PD=1.52u
M$244 VPWR \$I4196 \$I4195 VPWR sg13_lv_pmos L=0.5u W=1u AS=0.1523p AD=0.34p
+ PS=1.38u PD=2.68u
M$245 VGND \$I4198 \$I4197 VGND sg13_lv_nmos L=0.5u W=0.42u AS=0.1426p
+ AD=0.1428p PS=1.16u PD=1.52u
M$246 VGND \$I4197 \$567 VGND sg13_lv_nmos L=0.13u W=0.74u AS=0.1426p
+ AD=0.2516p PS=1.16u PD=2.16u
M$247 \$I4199 \$585 VGND VGND sg13_lv_nmos L=0.13u W=0.42u AS=0.1428p
+ AD=0.0798p PS=1.52u PD=0.8u
M$248 VGND \$I4199 \$I4198 VGND sg13_lv_nmos L=0.5u W=0.42u AS=0.0798p
+ AD=0.1428p PS=0.8u PD=1.52u
M$249 \$I4197 \$I4198 VPWR VPWR sg13_lv_pmos L=0.5u W=1u AS=0.34p AD=0.2254p
+ PS=2.68u PD=1.53u
M$250 VPWR \$I4197 \$567 VPWR sg13_lv_pmos L=0.13u W=1.12u AS=0.2254p
+ AD=0.4256p PS=1.53u PD=3u
M$251 VPWR \$585 \$I4199 VPWR sg13_lv_pmos L=0.13u W=0.42u AS=0.1523p
+ AD=0.1428p PS=1.38u PD=1.52u
M$252 VPWR \$I4199 \$I4198 VPWR sg13_lv_pmos L=0.5u W=1u AS=0.1523p AD=0.34p
+ PS=1.38u PD=2.68u
M$253 VGND \$I4201 \$I4200 VGND sg13_lv_nmos L=0.5u W=0.42u AS=0.1426p
+ AD=0.1428p PS=1.16u PD=1.52u
M$254 VGND \$I4200 \$691 VGND sg13_lv_nmos L=0.13u W=0.74u AS=0.1426p
+ AD=0.2516p PS=1.16u PD=2.16u
M$255 \$I4202 \$641 VGND VGND sg13_lv_nmos L=0.13u W=0.42u AS=0.1428p
+ AD=0.0798p PS=1.52u PD=0.8u
M$256 VGND \$I4202 \$I4201 VGND sg13_lv_nmos L=0.5u W=0.42u AS=0.0798p
+ AD=0.1428p PS=0.8u PD=1.52u
M$257 \$I4200 \$I4201 VPWR VPWR sg13_lv_pmos L=0.5u W=1u AS=0.34p AD=0.2254p
+ PS=2.68u PD=1.53u
M$258 VPWR \$I4200 \$691 VPWR sg13_lv_pmos L=0.13u W=1.12u AS=0.2254p
+ AD=0.4256p PS=1.53u PD=3u
M$259 VPWR \$641 \$I4202 VPWR sg13_lv_pmos L=0.13u W=0.42u AS=0.1523p
+ AD=0.1428p PS=1.38u PD=1.52u
M$260 VPWR \$I4202 \$I4201 VPWR sg13_lv_pmos L=0.5u W=1u AS=0.1523p AD=0.34p
+ PS=1.38u PD=2.68u
M$261 VGND \$I4204 \$I4203 VGND sg13_lv_nmos L=0.5u W=0.42u AS=0.1426p
+ AD=0.1428p PS=1.16u PD=1.52u
M$262 VGND \$I4203 \$629 VGND sg13_lv_nmos L=0.13u W=0.74u AS=0.1426p
+ AD=0.2516p PS=1.16u PD=2.16u
M$263 \$I4205 \$469 VGND VGND sg13_lv_nmos L=0.13u W=0.42u AS=0.1428p
+ AD=0.0798p PS=1.52u PD=0.8u
M$264 VGND \$I4205 \$I4204 VGND sg13_lv_nmos L=0.5u W=0.42u AS=0.0798p
+ AD=0.1428p PS=0.8u PD=1.52u
M$265 \$I4203 \$I4204 VPWR VPWR sg13_lv_pmos L=0.5u W=1u AS=0.34p AD=0.2254p
+ PS=2.68u PD=1.53u
M$266 VPWR \$I4203 \$629 VPWR sg13_lv_pmos L=0.13u W=1.12u AS=0.2254p
+ AD=0.4256p PS=1.53u PD=3u
M$267 VPWR \$469 \$I4205 VPWR sg13_lv_pmos L=0.13u W=0.42u AS=0.1523p
+ AD=0.1428p PS=1.38u PD=1.52u
M$268 VPWR \$I4205 \$I4204 VPWR sg13_lv_pmos L=0.5u W=1u AS=0.1523p AD=0.34p
+ PS=1.38u PD=2.68u
M$269 VGND \$I4207 \$I4206 VGND sg13_lv_nmos L=0.5u W=0.42u AS=0.1426p
+ AD=0.1428p PS=1.16u PD=1.52u
M$270 VGND \$I4206 \$606 VGND sg13_lv_nmos L=0.13u W=0.74u AS=0.1426p
+ AD=0.2516p PS=1.16u PD=2.16u
M$271 \$I4208 \$490 VGND VGND sg13_lv_nmos L=0.13u W=0.42u AS=0.1428p
+ AD=0.0798p PS=1.52u PD=0.8u
M$272 VGND \$I4208 \$I4207 VGND sg13_lv_nmos L=0.5u W=0.42u AS=0.0798p
+ AD=0.1428p PS=0.8u PD=1.52u
M$273 \$I4206 \$I4207 VPWR VPWR sg13_lv_pmos L=0.5u W=1u AS=0.34p AD=0.2254p
+ PS=2.68u PD=1.53u
M$274 VPWR \$I4206 \$606 VPWR sg13_lv_pmos L=0.13u W=1.12u AS=0.2254p
+ AD=0.4256p PS=1.53u PD=3u
M$275 VPWR \$490 \$I4208 VPWR sg13_lv_pmos L=0.13u W=0.42u AS=0.1523p
+ AD=0.1428p PS=1.38u PD=1.52u
M$276 VPWR \$I4208 \$I4207 VPWR sg13_lv_pmos L=0.5u W=1u AS=0.1523p AD=0.34p
+ PS=1.38u PD=2.68u
M$277 VGND \$I4210 \$I4209 VGND sg13_lv_nmos L=0.5u W=0.42u AS=0.1426p
+ AD=0.1428p PS=1.16u PD=1.52u
M$278 VGND \$I4209 \$661 VGND sg13_lv_nmos L=0.13u W=0.74u AS=0.1426p
+ AD=0.2516p PS=1.16u PD=2.16u
M$279 \$I4211 \$655 VGND VGND sg13_lv_nmos L=0.13u W=0.42u AS=0.1428p
+ AD=0.0798p PS=1.52u PD=0.8u
M$280 VGND \$I4211 \$I4210 VGND sg13_lv_nmos L=0.5u W=0.42u AS=0.0798p
+ AD=0.1428p PS=0.8u PD=1.52u
M$281 \$I4209 \$I4210 VPWR VPWR sg13_lv_pmos L=0.5u W=1u AS=0.34p AD=0.2254p
+ PS=2.68u PD=1.53u
M$282 VPWR \$I4209 \$661 VPWR sg13_lv_pmos L=0.13u W=1.12u AS=0.2254p
+ AD=0.4256p PS=1.53u PD=3u
M$283 VPWR \$655 \$I4211 VPWR sg13_lv_pmos L=0.13u W=0.42u AS=0.1523p
+ AD=0.1428p PS=1.38u PD=1.52u
M$284 VPWR \$I4211 \$I4210 VPWR sg13_lv_pmos L=0.5u W=1u AS=0.1523p AD=0.34p
+ PS=1.38u PD=2.68u
M$285 VGND \$I4213 \$I4212 VGND sg13_lv_nmos L=0.5u W=0.42u AS=0.1426p
+ AD=0.1428p PS=1.16u PD=1.52u
M$286 VGND \$I4212 \$747 VGND sg13_lv_nmos L=0.13u W=0.74u AS=0.1426p
+ AD=0.2516p PS=1.16u PD=2.16u
M$287 \$I4214 \$741 VGND VGND sg13_lv_nmos L=0.13u W=0.42u AS=0.1428p
+ AD=0.0798p PS=1.52u PD=0.8u
M$288 VGND \$I4214 \$I4213 VGND sg13_lv_nmos L=0.5u W=0.42u AS=0.0798p
+ AD=0.1428p PS=0.8u PD=1.52u
M$289 \$I4212 \$I4213 VPWR VPWR sg13_lv_pmos L=0.5u W=1u AS=0.34p AD=0.2254p
+ PS=2.68u PD=1.53u
M$290 VPWR \$I4212 \$747 VPWR sg13_lv_pmos L=0.13u W=1.12u AS=0.2254p
+ AD=0.4256p PS=1.53u PD=3u
M$291 VPWR \$741 \$I4214 VPWR sg13_lv_pmos L=0.13u W=0.42u AS=0.1523p
+ AD=0.1428p PS=1.38u PD=1.52u
M$292 VPWR \$I4214 \$I4213 VPWR sg13_lv_pmos L=0.5u W=1u AS=0.1523p AD=0.34p
+ PS=1.38u PD=2.68u
M$293 VGND \$I4216 \$I4215 VGND sg13_lv_nmos L=0.5u W=0.42u AS=0.1426p
+ AD=0.1428p PS=1.16u PD=1.52u
M$294 VGND \$I4215 \$795 VGND sg13_lv_nmos L=0.13u W=0.74u AS=0.1426p
+ AD=0.2516p PS=1.16u PD=2.16u
M$295 \$I4217 \$743 VGND VGND sg13_lv_nmos L=0.13u W=0.42u AS=0.1428p
+ AD=0.0798p PS=1.52u PD=0.8u
M$296 VGND \$I4217 \$I4216 VGND sg13_lv_nmos L=0.5u W=0.42u AS=0.0798p
+ AD=0.1428p PS=0.8u PD=1.52u
M$297 \$I4215 \$I4216 VPWR VPWR sg13_lv_pmos L=0.5u W=1u AS=0.34p AD=0.2254p
+ PS=2.68u PD=1.53u
M$298 VPWR \$I4215 \$795 VPWR sg13_lv_pmos L=0.13u W=1.12u AS=0.2254p
+ AD=0.4256p PS=1.53u PD=3u
M$299 VPWR \$743 \$I4217 VPWR sg13_lv_pmos L=0.13u W=0.42u AS=0.1523p
+ AD=0.1428p PS=1.38u PD=1.52u
M$300 VPWR \$I4217 \$I4216 VPWR sg13_lv_pmos L=0.5u W=1u AS=0.1523p AD=0.34p
+ PS=1.38u PD=2.68u
M$301 VGND \$I4219 \$I4218 VGND sg13_lv_nmos L=0.5u W=0.42u AS=0.1426p
+ AD=0.1428p PS=1.16u PD=1.52u
M$302 VGND \$I4218 \$745 VGND sg13_lv_nmos L=0.13u W=0.74u AS=0.1426p
+ AD=0.2516p PS=1.16u PD=2.16u
M$303 \$I4220 \$643 VGND VGND sg13_lv_nmos L=0.13u W=0.42u AS=0.1428p
+ AD=0.0798p PS=1.52u PD=0.8u
M$304 VGND \$I4220 \$I4219 VGND sg13_lv_nmos L=0.5u W=0.42u AS=0.0798p
+ AD=0.1428p PS=0.8u PD=1.52u
M$305 \$I4218 \$I4219 VPWR VPWR sg13_lv_pmos L=0.5u W=1u AS=0.34p AD=0.2254p
+ PS=2.68u PD=1.53u
M$306 VPWR \$I4218 \$745 VPWR sg13_lv_pmos L=0.13u W=1.12u AS=0.2254p
+ AD=0.4256p PS=1.53u PD=3u
M$307 VPWR \$643 \$I4220 VPWR sg13_lv_pmos L=0.13u W=0.42u AS=0.1523p
+ AD=0.1428p PS=1.38u PD=1.52u
M$308 VPWR \$I4220 \$I4219 VPWR sg13_lv_pmos L=0.5u W=1u AS=0.1523p AD=0.34p
+ PS=1.38u PD=2.68u
M$309 VGND \$I4222 \$I4221 VGND sg13_lv_nmos L=0.5u W=0.42u AS=0.1426p
+ AD=0.1428p PS=1.16u PD=1.52u
M$310 VGND \$I4221 \$717 VGND sg13_lv_nmos L=0.13u W=0.74u AS=0.1426p
+ AD=0.2516p PS=1.16u PD=2.16u
M$311 \$I4223 \$600 VGND VGND sg13_lv_nmos L=0.13u W=0.42u AS=0.1428p
+ AD=0.0798p PS=1.52u PD=0.8u
M$312 VGND \$I4223 \$I4222 VGND sg13_lv_nmos L=0.5u W=0.42u AS=0.0798p
+ AD=0.1428p PS=0.8u PD=1.52u
M$313 \$I4221 \$I4222 VPWR VPWR sg13_lv_pmos L=0.5u W=1u AS=0.34p AD=0.2254p
+ PS=2.68u PD=1.53u
M$314 VPWR \$I4221 \$717 VPWR sg13_lv_pmos L=0.13u W=1.12u AS=0.2254p
+ AD=0.4256p PS=1.53u PD=3u
M$315 VPWR \$600 \$I4223 VPWR sg13_lv_pmos L=0.13u W=0.42u AS=0.1523p
+ AD=0.1428p PS=1.38u PD=1.52u
M$316 VPWR \$I4223 \$I4222 VPWR sg13_lv_pmos L=0.5u W=1u AS=0.1523p AD=0.34p
+ PS=1.38u PD=2.68u
M$317 VGND \$I4225 \$I4224 VGND sg13_lv_nmos L=0.5u W=0.42u AS=0.1426p
+ AD=0.1428p PS=1.16u PD=1.52u
M$318 VGND \$I4224 \$753 VGND sg13_lv_nmos L=0.13u W=0.74u AS=0.1426p
+ AD=0.2516p PS=1.16u PD=2.16u
M$319 \$I4226 \$754 VGND VGND sg13_lv_nmos L=0.13u W=0.42u AS=0.1428p
+ AD=0.0798p PS=1.52u PD=0.8u
M$320 VGND \$I4226 \$I4225 VGND sg13_lv_nmos L=0.5u W=0.42u AS=0.0798p
+ AD=0.1428p PS=0.8u PD=1.52u
M$321 \$I4224 \$I4225 VPWR VPWR sg13_lv_pmos L=0.5u W=1u AS=0.34p AD=0.2254p
+ PS=2.68u PD=1.53u
M$322 VPWR \$I4224 \$753 VPWR sg13_lv_pmos L=0.13u W=1.12u AS=0.2254p
+ AD=0.4256p PS=1.53u PD=3u
M$323 VPWR \$754 \$I4226 VPWR sg13_lv_pmos L=0.13u W=0.42u AS=0.1523p
+ AD=0.1428p PS=1.38u PD=1.52u
M$324 VPWR \$I4226 \$I4225 VPWR sg13_lv_pmos L=0.5u W=1u AS=0.1523p AD=0.34p
+ PS=1.38u PD=2.68u
M$325 VGND \$I4228 \$I4227 VGND sg13_lv_nmos L=0.5u W=0.42u AS=0.1426p
+ AD=0.1428p PS=1.16u PD=1.52u
M$326 VGND \$I4227 \$805 VGND sg13_lv_nmos L=0.13u W=0.74u AS=0.1426p
+ AD=0.2516p PS=1.16u PD=2.16u
M$327 \$I4229 \$776 VGND VGND sg13_lv_nmos L=0.13u W=0.42u AS=0.1428p
+ AD=0.0798p PS=1.52u PD=0.8u
M$328 VGND \$I4229 \$I4228 VGND sg13_lv_nmos L=0.5u W=0.42u AS=0.0798p
+ AD=0.1428p PS=0.8u PD=1.52u
M$329 \$I4227 \$I4228 VPWR VPWR sg13_lv_pmos L=0.5u W=1u AS=0.34p AD=0.2254p
+ PS=2.68u PD=1.53u
M$330 VPWR \$I4227 \$805 VPWR sg13_lv_pmos L=0.13u W=1.12u AS=0.2254p
+ AD=0.4256p PS=1.53u PD=3u
M$331 VPWR \$776 \$I4229 VPWR sg13_lv_pmos L=0.13u W=0.42u AS=0.1523p
+ AD=0.1428p PS=1.38u PD=1.52u
M$332 VPWR \$I4229 \$I4228 VPWR sg13_lv_pmos L=0.5u W=1u AS=0.1523p AD=0.34p
+ PS=1.38u PD=2.68u
M$333 VGND \$I4231 \$I4230 VGND sg13_lv_nmos L=0.5u W=0.42u AS=0.1426p
+ AD=0.1428p PS=1.16u PD=1.52u
M$334 VGND \$I4230 \$774 VGND sg13_lv_nmos L=0.13u W=0.74u AS=0.1426p
+ AD=0.2516p PS=1.16u PD=2.16u
M$335 \$I4232 \$818 VGND VGND sg13_lv_nmos L=0.13u W=0.42u AS=0.1428p
+ AD=0.0798p PS=1.52u PD=0.8u
M$336 VGND \$I4232 \$I4231 VGND sg13_lv_nmos L=0.5u W=0.42u AS=0.0798p
+ AD=0.1428p PS=0.8u PD=1.52u
M$337 \$I4230 \$I4231 VPWR VPWR sg13_lv_pmos L=0.5u W=1u AS=0.34p AD=0.2254p
+ PS=2.68u PD=1.53u
M$338 VPWR \$I4230 \$774 VPWR sg13_lv_pmos L=0.13u W=1.12u AS=0.2254p
+ AD=0.4256p PS=1.53u PD=3u
M$339 VPWR \$818 \$I4232 VPWR sg13_lv_pmos L=0.13u W=0.42u AS=0.1523p
+ AD=0.1428p PS=1.38u PD=1.52u
M$340 VPWR \$I4232 \$I4231 VPWR sg13_lv_pmos L=0.5u W=1u AS=0.1523p AD=0.34p
+ PS=1.38u PD=2.68u
M$341 VGND \$I4234 \$I4233 VGND sg13_lv_nmos L=0.5u W=0.42u AS=0.1426p
+ AD=0.1428p PS=1.16u PD=1.52u
M$342 VGND \$I4233 \$750 VGND sg13_lv_nmos L=0.13u W=0.74u AS=0.1426p
+ AD=0.2516p PS=1.16u PD=2.16u
M$343 \$I4235 \$808 VGND VGND sg13_lv_nmos L=0.13u W=0.42u AS=0.1428p
+ AD=0.0798p PS=1.52u PD=0.8u
M$344 VGND \$I4235 \$I4234 VGND sg13_lv_nmos L=0.5u W=0.42u AS=0.0798p
+ AD=0.1428p PS=0.8u PD=1.52u
M$345 \$I4233 \$I4234 VPWR VPWR sg13_lv_pmos L=0.5u W=1u AS=0.34p AD=0.2254p
+ PS=2.68u PD=1.53u
M$346 VPWR \$I4233 \$750 VPWR sg13_lv_pmos L=0.13u W=1.12u AS=0.2254p
+ AD=0.4256p PS=1.53u PD=3u
M$347 VPWR \$808 \$I4235 VPWR sg13_lv_pmos L=0.13u W=0.42u AS=0.1523p
+ AD=0.1428p PS=1.38u PD=1.52u
M$348 VPWR \$I4235 \$I4234 VPWR sg13_lv_pmos L=0.5u W=1u AS=0.1523p AD=0.34p
+ PS=1.38u PD=2.68u
M$349 VGND \$I4237 \$I4236 VGND sg13_lv_nmos L=0.5u W=0.42u AS=0.1426p
+ AD=0.1428p PS=1.16u PD=1.52u
M$350 VGND \$I4236 \$771 VGND sg13_lv_nmos L=0.13u W=0.74u AS=0.1426p
+ AD=0.2516p PS=1.16u PD=2.16u
M$351 \$I4238 \$247 VGND VGND sg13_lv_nmos L=0.13u W=0.42u AS=0.1428p
+ AD=0.0798p PS=1.52u PD=0.8u
M$352 VGND \$I4238 \$I4237 VGND sg13_lv_nmos L=0.5u W=0.42u AS=0.0798p
+ AD=0.1428p PS=0.8u PD=1.52u
M$353 \$I4236 \$I4237 VPWR VPWR sg13_lv_pmos L=0.5u W=1u AS=0.34p AD=0.2254p
+ PS=2.68u PD=1.53u
M$354 VPWR \$I4236 \$771 VPWR sg13_lv_pmos L=0.13u W=1.12u AS=0.2254p
+ AD=0.4256p PS=1.53u PD=3u
M$355 VPWR \$247 \$I4238 VPWR sg13_lv_pmos L=0.13u W=0.42u AS=0.1523p
+ AD=0.1428p PS=1.38u PD=1.52u
M$356 VPWR \$I4238 \$I4237 VPWR sg13_lv_pmos L=0.5u W=1u AS=0.1523p AD=0.34p
+ PS=1.38u PD=2.68u
M$357 VGND \$I4240 \$I4239 VGND sg13_lv_nmos L=0.5u W=0.42u AS=0.1426p
+ AD=0.1428p PS=1.16u PD=1.52u
M$358 VGND \$I4239 \$681 VGND sg13_lv_nmos L=0.13u W=0.74u AS=0.1426p
+ AD=0.2516p PS=1.16u PD=2.16u
M$359 \$I4241 \$817 VGND VGND sg13_lv_nmos L=0.13u W=0.42u AS=0.1428p
+ AD=0.0798p PS=1.52u PD=0.8u
M$360 VGND \$I4241 \$I4240 VGND sg13_lv_nmos L=0.5u W=0.42u AS=0.0798p
+ AD=0.1428p PS=0.8u PD=1.52u
M$361 \$I4239 \$I4240 VPWR VPWR sg13_lv_pmos L=0.5u W=1u AS=0.34p AD=0.2254p
+ PS=2.68u PD=1.53u
M$362 VPWR \$I4239 \$681 VPWR sg13_lv_pmos L=0.13u W=1.12u AS=0.2254p
+ AD=0.4256p PS=1.53u PD=3u
M$363 VPWR \$817 \$I4241 VPWR sg13_lv_pmos L=0.13u W=0.42u AS=0.1523p
+ AD=0.1428p PS=1.38u PD=1.52u
M$364 VPWR \$I4241 \$I4240 VPWR sg13_lv_pmos L=0.5u W=1u AS=0.1523p AD=0.34p
+ PS=1.38u PD=2.68u
M$365 VGND \$I4243 \$I4242 VGND sg13_lv_nmos L=0.5u W=0.42u AS=0.1426p
+ AD=0.1428p PS=1.16u PD=1.52u
M$366 VGND \$I4242 \$888 VGND sg13_lv_nmos L=0.13u W=0.74u AS=0.1426p
+ AD=0.2516p PS=1.16u PD=2.16u
M$367 \$I4244 \$859 VGND VGND sg13_lv_nmos L=0.13u W=0.42u AS=0.1428p
+ AD=0.0798p PS=1.52u PD=0.8u
M$368 VGND \$I4244 \$I4243 VGND sg13_lv_nmos L=0.5u W=0.42u AS=0.0798p
+ AD=0.1428p PS=0.8u PD=1.52u
M$369 \$I4242 \$I4243 VPWR VPWR sg13_lv_pmos L=0.5u W=1u AS=0.34p AD=0.2254p
+ PS=2.68u PD=1.53u
M$370 VPWR \$I4242 \$888 VPWR sg13_lv_pmos L=0.13u W=1.12u AS=0.2254p
+ AD=0.4256p PS=1.53u PD=3u
M$371 VPWR \$859 \$I4244 VPWR sg13_lv_pmos L=0.13u W=0.42u AS=0.1523p
+ AD=0.1428p PS=1.38u PD=1.52u
M$372 VPWR \$I4244 \$I4243 VPWR sg13_lv_pmos L=0.5u W=1u AS=0.1523p AD=0.34p
+ PS=1.38u PD=2.68u
M$373 VGND \$I4246 \$I4245 VGND sg13_lv_nmos L=0.5u W=0.42u AS=0.1426p
+ AD=0.1428p PS=1.16u PD=1.52u
M$374 VGND \$I4245 \$782 VGND sg13_lv_nmos L=0.13u W=0.74u AS=0.1426p
+ AD=0.2516p PS=1.16u PD=2.16u
M$375 \$I4247 \$869 VGND VGND sg13_lv_nmos L=0.13u W=0.42u AS=0.1428p
+ AD=0.0798p PS=1.52u PD=0.8u
M$376 VGND \$I4247 \$I4246 VGND sg13_lv_nmos L=0.5u W=0.42u AS=0.0798p
+ AD=0.1428p PS=0.8u PD=1.52u
M$377 \$I4245 \$I4246 VPWR VPWR sg13_lv_pmos L=0.5u W=1u AS=0.34p AD=0.2254p
+ PS=2.68u PD=1.53u
M$378 VPWR \$I4245 \$782 VPWR sg13_lv_pmos L=0.13u W=1.12u AS=0.2254p
+ AD=0.4256p PS=1.53u PD=3u
M$379 VPWR \$869 \$I4247 VPWR sg13_lv_pmos L=0.13u W=0.42u AS=0.1523p
+ AD=0.1428p PS=1.38u PD=1.52u
M$380 VPWR \$I4247 \$I4246 VPWR sg13_lv_pmos L=0.5u W=1u AS=0.1523p AD=0.34p
+ PS=1.38u PD=2.68u
M$381 VGND \$I4249 \$I4248 VGND sg13_lv_nmos L=0.5u W=0.42u AS=0.1426p
+ AD=0.1428p PS=1.16u PD=1.52u
M$382 VGND \$I4248 \$865 VGND sg13_lv_nmos L=0.13u W=0.74u AS=0.1426p
+ AD=0.2516p PS=1.16u PD=2.16u
M$383 \$I4250 \$746 VGND VGND sg13_lv_nmos L=0.13u W=0.42u AS=0.1428p
+ AD=0.0798p PS=1.52u PD=0.8u
M$384 VGND \$I4250 \$I4249 VGND sg13_lv_nmos L=0.5u W=0.42u AS=0.0798p
+ AD=0.1428p PS=0.8u PD=1.52u
M$385 \$I4248 \$I4249 VPWR VPWR sg13_lv_pmos L=0.5u W=1u AS=0.34p AD=0.2254p
+ PS=2.68u PD=1.53u
M$386 VPWR \$I4248 \$865 VPWR sg13_lv_pmos L=0.13u W=1.12u AS=0.2254p
+ AD=0.4256p PS=1.53u PD=3u
M$387 VPWR \$746 \$I4250 VPWR sg13_lv_pmos L=0.13u W=0.42u AS=0.1523p
+ AD=0.1428p PS=1.38u PD=1.52u
M$388 VPWR \$I4250 \$I4249 VPWR sg13_lv_pmos L=0.5u W=1u AS=0.1523p AD=0.34p
+ PS=1.38u PD=2.68u
M$389 VGND \$I4252 \$I4251 VGND sg13_lv_nmos L=0.5u W=0.42u AS=0.1426p
+ AD=0.1428p PS=1.16u PD=1.52u
M$390 VGND \$I4251 \$821 VGND sg13_lv_nmos L=0.13u W=0.74u AS=0.1426p
+ AD=0.2516p PS=1.16u PD=2.16u
M$391 \$I4253 \$751 VGND VGND sg13_lv_nmos L=0.13u W=0.42u AS=0.1428p
+ AD=0.0798p PS=1.52u PD=0.8u
M$392 VGND \$I4253 \$I4252 VGND sg13_lv_nmos L=0.5u W=0.42u AS=0.0798p
+ AD=0.1428p PS=0.8u PD=1.52u
M$393 \$I4251 \$I4252 VPWR VPWR sg13_lv_pmos L=0.5u W=1u AS=0.34p AD=0.2254p
+ PS=2.68u PD=1.53u
M$394 VPWR \$I4251 \$821 VPWR sg13_lv_pmos L=0.13u W=1.12u AS=0.2254p
+ AD=0.4256p PS=1.53u PD=3u
M$395 VPWR \$751 \$I4253 VPWR sg13_lv_pmos L=0.13u W=0.42u AS=0.1523p
+ AD=0.1428p PS=1.38u PD=1.52u
M$396 VPWR \$I4253 \$I4252 VPWR sg13_lv_pmos L=0.5u W=1u AS=0.1523p AD=0.34p
+ PS=1.38u PD=2.68u
M$397 VGND \$I4255 \$I4254 VGND sg13_lv_nmos L=0.5u W=0.42u AS=0.1426p
+ AD=0.1428p PS=1.16u PD=1.52u
M$398 VGND \$I4254 \$909 VGND sg13_lv_nmos L=0.13u W=0.74u AS=0.1426p
+ AD=0.2516p PS=1.16u PD=2.16u
M$399 \$I4256 \$825 VGND VGND sg13_lv_nmos L=0.13u W=0.42u AS=0.1428p
+ AD=0.0798p PS=1.52u PD=0.8u
M$400 VGND \$I4256 \$I4255 VGND sg13_lv_nmos L=0.5u W=0.42u AS=0.0798p
+ AD=0.1428p PS=0.8u PD=1.52u
M$401 \$I4254 \$I4255 VPWR VPWR sg13_lv_pmos L=0.5u W=1u AS=0.34p AD=0.2254p
+ PS=2.68u PD=1.53u
M$402 VPWR \$I4254 \$909 VPWR sg13_lv_pmos L=0.13u W=1.12u AS=0.2254p
+ AD=0.4256p PS=1.53u PD=3u
M$403 VPWR \$825 \$I4256 VPWR sg13_lv_pmos L=0.13u W=0.42u AS=0.1523p
+ AD=0.1428p PS=1.38u PD=1.52u
M$404 VPWR \$I4256 \$I4255 VPWR sg13_lv_pmos L=0.5u W=1u AS=0.1523p AD=0.34p
+ PS=1.38u PD=2.68u
M$405 VGND \$I4258 \$I4257 VGND sg13_lv_nmos L=0.5u W=0.42u AS=0.1426p
+ AD=0.1428p PS=1.16u PD=1.52u
M$406 VGND \$I4257 \$822 VGND sg13_lv_nmos L=0.13u W=0.74u AS=0.1426p
+ AD=0.2516p PS=1.16u PD=2.16u
M$407 \$I4259 \$896 VGND VGND sg13_lv_nmos L=0.13u W=0.42u AS=0.1428p
+ AD=0.0798p PS=1.52u PD=0.8u
M$408 VGND \$I4259 \$I4258 VGND sg13_lv_nmos L=0.5u W=0.42u AS=0.0798p
+ AD=0.1428p PS=0.8u PD=1.52u
M$409 \$I4257 \$I4258 VPWR VPWR sg13_lv_pmos L=0.5u W=1u AS=0.34p AD=0.2254p
+ PS=2.68u PD=1.53u
M$410 VPWR \$I4257 \$822 VPWR sg13_lv_pmos L=0.13u W=1.12u AS=0.2254p
+ AD=0.4256p PS=1.53u PD=3u
M$411 VPWR \$896 \$I4259 VPWR sg13_lv_pmos L=0.13u W=0.42u AS=0.1523p
+ AD=0.1428p PS=1.38u PD=1.52u
M$412 VPWR \$I4259 \$I4258 VPWR sg13_lv_pmos L=0.5u W=1u AS=0.1523p AD=0.34p
+ PS=1.38u PD=2.68u
M$413 VGND \$I4260 \$392 VGND sg13_lv_nmos L=0.13u W=1.48u AS=0.3922p
+ AD=0.2777p PS=3.28u PD=2.24u
M$415 VGND rst \$I4260 VGND sg13_lv_nmos L=0.13u W=0.64u AS=0.1371p AD=0.2176p
+ PS=1.12u PD=1.96u
M$416 VPWR rst \$I4260 VPWR sg13_lv_pmos L=0.13u W=1u AS=0.2086p AD=0.34p
+ PS=1.5u PD=2.68u
M$417 VPWR \$I4260 \$392 VPWR sg13_lv_pmos L=0.13u W=2.24u AS=0.9464p
+ AD=0.4214p PS=5.05u PD=3u
M$419 \$I4261 \$265 VGND VGND sg13_lv_nmos L=0.13u W=2.22u AS=0.5365p
+ AD=0.4218p PS=4.41u PD=3.36u
M$422 VGND \$I4261 \$195 VGND sg13_lv_nmos L=0.13u W=5.92u AS=1.1248p
+ AD=1.2358p PS=8.96u PD=10u
M$430 \$I4261 \$265 VPWR VPWR sg13_lv_pmos L=0.13u W=3.36u AS=0.8064p
+ AD=0.6384p PS=5.92u PD=4.5u
M$433 VPWR \$I4261 \$195 VPWR sg13_lv_pmos L=0.13u W=8.96u AS=1.7024p AD=1.876p
+ PS=12u PD=13.43u
M$441 \$I4262 \$310 VGND VGND sg13_lv_nmos L=0.13u W=2.22u AS=0.5365p
+ AD=0.4218p PS=4.41u PD=3.36u
M$444 VGND \$I4262 \$52 VGND sg13_lv_nmos L=0.13u W=5.92u AS=1.1248p AD=1.2358p
+ PS=8.96u PD=10u
M$452 \$I4262 \$310 VPWR VPWR sg13_lv_pmos L=0.13u W=3.36u AS=0.8064p
+ AD=0.6384p PS=5.92u PD=4.5u
M$455 VPWR \$I4262 \$52 VPWR sg13_lv_pmos L=0.13u W=8.96u AS=1.7024p AD=1.876p
+ PS=12u PD=13.43u
M$463 \$I4263 \$310 VGND VGND sg13_lv_nmos L=0.13u W=2.22u AS=0.5365p
+ AD=0.4218p PS=4.41u PD=3.36u
M$466 VGND \$I4263 \$15 VGND sg13_lv_nmos L=0.13u W=5.92u AS=1.1248p AD=1.2358p
+ PS=8.96u PD=10u
M$474 \$I4263 \$310 VPWR VPWR sg13_lv_pmos L=0.13u W=3.36u AS=0.8064p
+ AD=0.6384p PS=5.92u PD=4.5u
M$477 VPWR \$I4263 \$15 VPWR sg13_lv_pmos L=0.13u W=8.96u AS=1.7024p AD=1.876p
+ PS=12u PD=13.43u
M$485 \$I4264 \$392 VGND VGND sg13_lv_nmos L=0.13u W=2.22u AS=0.5365p
+ AD=0.4218p PS=4.41u PD=3.36u
M$488 VGND \$I4264 \$16 VGND sg13_lv_nmos L=0.13u W=5.92u AS=1.1248p AD=1.2358p
+ PS=8.96u PD=10u
M$496 \$I4264 \$392 VPWR VPWR sg13_lv_pmos L=0.13u W=3.36u AS=0.8064p
+ AD=0.6384p PS=5.92u PD=4.5u
M$499 VPWR \$I4264 \$16 VPWR sg13_lv_pmos L=0.13u W=8.96u AS=1.7024p AD=1.876p
+ PS=12u PD=13.43u
M$507 \$I4265 \$392 VGND VGND sg13_lv_nmos L=0.13u W=2.22u AS=0.5365p
+ AD=0.4218p PS=4.41u PD=3.36u
M$510 VGND \$I4265 \$44 VGND sg13_lv_nmos L=0.13u W=5.92u AS=1.1248p AD=1.2358p
+ PS=8.96u PD=10u
M$518 \$I4265 \$392 VPWR VPWR sg13_lv_pmos L=0.13u W=3.36u AS=0.8064p
+ AD=0.6384p PS=5.92u PD=4.5u
M$521 VPWR \$I4265 \$44 VPWR sg13_lv_pmos L=0.13u W=8.96u AS=1.7024p AD=1.876p
+ PS=12u PD=13.43u
M$529 \$I4266 \$526 VGND VGND sg13_lv_nmos L=0.13u W=2.22u AS=0.5365p
+ AD=0.4218p PS=4.41u PD=3.36u
M$532 VGND \$I4266 \$58 VGND sg13_lv_nmos L=0.13u W=5.92u AS=1.1248p AD=1.2358p
+ PS=8.96u PD=10u
M$540 \$I4266 \$526 VPWR VPWR sg13_lv_pmos L=0.13u W=3.36u AS=0.8064p
+ AD=0.6384p PS=5.92u PD=4.5u
M$543 VPWR \$I4266 \$58 VPWR sg13_lv_pmos L=0.13u W=8.96u AS=1.7024p AD=1.876p
+ PS=12u PD=13.43u
M$551 \$I4267 \$335 VGND VGND sg13_lv_nmos L=0.13u W=2.22u AS=0.5365p
+ AD=0.4218p PS=4.41u PD=3.36u
M$554 VGND \$I4267 \$59 VGND sg13_lv_nmos L=0.13u W=5.92u AS=1.1248p AD=1.2358p
+ PS=8.96u PD=10u
M$562 \$I4267 \$335 VPWR VPWR sg13_lv_pmos L=0.13u W=3.36u AS=0.8064p
+ AD=0.6384p PS=5.92u PD=4.5u
M$565 VPWR \$I4267 \$59 VPWR sg13_lv_pmos L=0.13u W=8.96u AS=1.7024p AD=1.876p
+ PS=12u PD=13.43u
M$573 \$I4268 clk VGND VGND sg13_lv_nmos L=0.13u W=2.22u AS=0.5365p AD=0.4218p
+ PS=4.41u PD=3.36u
M$576 VGND \$I4268 \$310 VGND sg13_lv_nmos L=0.13u W=5.92u AS=1.1248p
+ AD=1.2358p PS=8.96u PD=10u
M$584 \$I4268 clk VPWR VPWR sg13_lv_pmos L=0.13u W=3.36u AS=0.8064p AD=0.6384p
+ PS=5.92u PD=4.5u
M$587 VPWR \$I4268 \$310 VPWR sg13_lv_pmos L=0.13u W=8.96u AS=1.7024p AD=1.876p
+ PS=12u PD=13.43u
M$595 \$I4269 \$394 VGND VGND sg13_lv_nmos L=0.13u W=2.22u AS=0.5365p
+ AD=0.4218p PS=4.41u PD=3.36u
M$598 VGND \$I4269 \$174 VGND sg13_lv_nmos L=0.13u W=5.92u AS=1.1248p
+ AD=1.2358p PS=8.96u PD=10u
M$606 \$I4269 \$394 VPWR VPWR sg13_lv_pmos L=0.13u W=3.36u AS=0.8064p
+ AD=0.6384p PS=5.92u PD=4.5u
M$609 VPWR \$I4269 \$174 VPWR sg13_lv_pmos L=0.13u W=8.96u AS=1.7024p AD=1.876p
+ PS=12u PD=13.43u
M$617 \$I4270 \$458 VGND VGND sg13_lv_nmos L=0.13u W=2.22u AS=0.5365p
+ AD=0.4218p PS=4.41u PD=3.36u
M$620 VGND \$I4270 \$43 VGND sg13_lv_nmos L=0.13u W=5.92u AS=1.1248p AD=1.2358p
+ PS=8.96u PD=10u
M$628 \$I4270 \$458 VPWR VPWR sg13_lv_pmos L=0.13u W=3.36u AS=0.8064p
+ AD=0.6384p PS=5.92u PD=4.5u
M$631 VPWR \$I4270 \$43 VPWR sg13_lv_pmos L=0.13u W=8.96u AS=1.7024p AD=1.876p
+ PS=12u PD=13.43u
M$639 \$I4271 \$600 VGND VGND sg13_lv_nmos L=0.13u W=2.22u AS=0.5365p
+ AD=0.4218p PS=4.41u PD=3.36u
M$642 VGND \$I4271 \$64 VGND sg13_lv_nmos L=0.13u W=5.92u AS=1.1248p AD=1.2358p
+ PS=8.96u PD=10u
M$650 \$I4271 \$600 VPWR VPWR sg13_lv_pmos L=0.13u W=3.36u AS=0.8064p
+ AD=0.6384p PS=5.92u PD=4.5u
M$653 VPWR \$I4271 \$64 VPWR sg13_lv_pmos L=0.13u W=8.96u AS=1.7024p AD=1.876p
+ PS=12u PD=13.43u
M$661 \$I4272 \$545 VGND VGND sg13_lv_nmos L=0.13u W=2.22u AS=0.5365p
+ AD=0.4218p PS=4.41u PD=3.36u
M$664 VGND \$I4272 \$63 VGND sg13_lv_nmos L=0.13u W=5.92u AS=1.1248p AD=1.2358p
+ PS=8.96u PD=10u
M$672 \$I4272 \$545 VPWR VPWR sg13_lv_pmos L=0.13u W=3.36u AS=0.8064p
+ AD=0.6384p PS=5.92u PD=4.5u
M$675 VPWR \$I4272 \$63 VPWR sg13_lv_pmos L=0.13u W=8.96u AS=1.7024p AD=1.876p
+ PS=12u PD=13.43u
M$683 \$I4273 \$717 VGND VGND sg13_lv_nmos L=0.13u W=2.22u AS=0.5365p
+ AD=0.4218p PS=4.41u PD=3.36u
M$686 VGND \$I4273 \$68 VGND sg13_lv_nmos L=0.13u W=5.92u AS=1.1248p AD=1.2358p
+ PS=8.96u PD=10u
M$694 \$I4273 \$717 VPWR VPWR sg13_lv_pmos L=0.13u W=3.36u AS=0.8064p
+ AD=0.6384p PS=5.92u PD=4.5u
M$697 VPWR \$I4273 \$68 VPWR sg13_lv_pmos L=0.13u W=8.96u AS=1.7024p AD=1.876p
+ PS=12u PD=13.43u
M$705 \$I4274 \$310 VGND VGND sg13_lv_nmos L=0.13u W=2.22u AS=0.5365p
+ AD=0.4218p PS=4.41u PD=3.36u
M$708 VGND \$I4274 \$587 VGND sg13_lv_nmos L=0.13u W=5.92u AS=1.1248p
+ AD=1.2358p PS=8.96u PD=10u
M$716 \$I4274 \$310 VPWR VPWR sg13_lv_pmos L=0.13u W=3.36u AS=0.8064p
+ AD=0.6384p PS=5.92u PD=4.5u
M$719 VPWR \$I4274 \$587 VPWR sg13_lv_pmos L=0.13u W=8.96u AS=1.7024p AD=1.876p
+ PS=12u PD=13.43u
M$727 \$I4275 \$310 VGND VGND sg13_lv_nmos L=0.13u W=2.22u AS=0.5365p
+ AD=0.4218p PS=4.41u PD=3.36u
M$730 VGND \$I4275 \$608 VGND sg13_lv_nmos L=0.13u W=5.92u AS=1.1248p
+ AD=1.2358p PS=8.96u PD=10u
M$738 \$I4275 \$310 VPWR VPWR sg13_lv_pmos L=0.13u W=3.36u AS=0.8064p
+ AD=0.6384p PS=5.92u PD=4.5u
M$741 VPWR \$I4275 \$608 VPWR sg13_lv_pmos L=0.13u W=8.96u AS=1.7024p AD=1.876p
+ PS=12u PD=13.43u
M$749 VGND \$19 \$I4276 VGND sg13_lv_nmos L=0.13u W=0.55u AS=0.14875p AD=0.187p
+ PS=1.16u PD=1.78u
M$750 VGND \$I4276 B[0] VGND sg13_lv_nmos L=0.13u W=0.74u AS=0.14875p
+ AD=0.2886p PS=1.16u PD=2.26u
M$751 VPWR \$19 \$I4276 VPWR sg13_lv_pmos L=0.13u W=0.84u AS=0.2114p AD=0.2856p
+ PS=1.54u PD=2.36u
M$752 VPWR \$I4276 B[0] VPWR sg13_lv_pmos L=0.13u W=1.12u AS=0.2114p AD=0.42p
+ PS=1.54u PD=2.99u
M$753 VGND \$83 \$I4277 VGND sg13_lv_nmos L=0.13u W=0.55u AS=0.14875p AD=0.187p
+ PS=1.16u PD=1.78u
M$754 VGND \$I4277 D[1] VGND sg13_lv_nmos L=0.13u W=0.74u AS=0.14875p
+ AD=0.2886p PS=1.16u PD=2.26u
M$755 VPWR \$83 \$I4277 VPWR sg13_lv_pmos L=0.13u W=0.84u AS=0.2114p AD=0.2856p
+ PS=1.54u PD=2.36u
M$756 VPWR \$I4277 D[1] VPWR sg13_lv_pmos L=0.13u W=1.12u AS=0.2114p AD=0.42p
+ PS=1.54u PD=2.99u
M$757 VGND Om \$I4278 VGND sg13_lv_nmos L=0.13u W=0.55u AS=0.14875p AD=0.187p
+ PS=1.16u PD=1.78u
M$758 VGND \$I4278 \$28 VGND sg13_lv_nmos L=0.13u W=0.74u AS=0.14875p
+ AD=0.2886p PS=1.16u PD=2.26u
M$759 VPWR Om \$I4278 VPWR sg13_lv_pmos L=0.13u W=0.84u AS=0.2114p AD=0.2856p
+ PS=1.54u PD=2.36u
M$760 VPWR \$I4278 \$28 VPWR sg13_lv_pmos L=0.13u W=1.12u AS=0.2114p AD=0.42p
+ PS=1.54u PD=2.99u
M$761 VGND Op \$I4279 VGND sg13_lv_nmos L=0.13u W=0.55u AS=0.14875p AD=0.187p
+ PS=1.16u PD=1.78u
M$762 VGND \$I4279 \$20 VGND sg13_lv_nmos L=0.13u W=0.74u AS=0.14875p
+ AD=0.2886p PS=1.16u PD=2.26u
M$763 VPWR Op \$I4279 VPWR sg13_lv_pmos L=0.13u W=0.84u AS=0.2114p AD=0.2856p
+ PS=1.54u PD=2.36u
M$764 VPWR \$I4279 \$20 VPWR sg13_lv_pmos L=0.13u W=1.12u AS=0.2114p AD=0.42p
+ PS=1.54u PD=2.99u
M$765 VGND \$34 \$I4280 VGND sg13_lv_nmos L=0.13u W=0.55u AS=0.14875p AD=0.187p
+ PS=1.16u PD=1.78u
M$766 VGND \$I4280 BN[0] VGND sg13_lv_nmos L=0.13u W=0.74u AS=0.14875p
+ AD=0.2886p PS=1.16u PD=2.26u
M$767 VPWR \$34 \$I4280 VPWR sg13_lv_pmos L=0.13u W=0.84u AS=0.2114p AD=0.2856p
+ PS=1.54u PD=2.36u
M$768 VPWR \$I4280 BN[0] VPWR sg13_lv_pmos L=0.13u W=1.12u AS=0.2114p AD=0.42p
+ PS=1.54u PD=2.99u
M$769 VGND \$35 \$I4281 VGND sg13_lv_nmos L=0.13u W=0.55u AS=0.14875p AD=0.187p
+ PS=1.16u PD=1.78u
M$770 VGND \$I4281 B[3] VGND sg13_lv_nmos L=0.13u W=0.74u AS=0.14875p
+ AD=0.2886p PS=1.16u PD=2.26u
M$771 VPWR \$35 \$I4281 VPWR sg13_lv_pmos L=0.13u W=0.84u AS=0.2114p AD=0.2856p
+ PS=1.54u PD=2.36u
M$772 VPWR \$I4281 B[3] VPWR sg13_lv_pmos L=0.13u W=1.12u AS=0.2114p AD=0.42p
+ PS=1.54u PD=2.99u
M$773 VGND \$65 \$I4282 VGND sg13_lv_nmos L=0.13u W=0.55u AS=0.14875p AD=0.187p
+ PS=1.16u PD=1.78u
M$774 VGND \$I4282 BN[3] VGND sg13_lv_nmos L=0.13u W=0.74u AS=0.14875p
+ AD=0.2886p PS=1.16u PD=2.26u
M$775 VPWR \$65 \$I4282 VPWR sg13_lv_pmos L=0.13u W=0.84u AS=0.2114p AD=0.2856p
+ PS=1.54u PD=2.36u
M$776 VPWR \$I4282 BN[3] VPWR sg13_lv_pmos L=0.13u W=1.12u AS=0.2114p AD=0.42p
+ PS=1.54u PD=2.99u
M$777 VGND \$75 \$I4283 VGND sg13_lv_nmos L=0.13u W=0.55u AS=0.14875p AD=0.187p
+ PS=1.16u PD=1.78u
M$778 VGND \$I4283 BN[8] VGND sg13_lv_nmos L=0.13u W=0.74u AS=0.14875p
+ AD=0.2886p PS=1.16u PD=2.26u
M$779 VPWR \$75 \$I4283 VPWR sg13_lv_pmos L=0.13u W=0.84u AS=0.2114p AD=0.2856p
+ PS=1.54u PD=2.36u
M$780 VPWR \$I4283 BN[8] VPWR sg13_lv_pmos L=0.13u W=1.12u AS=0.2114p AD=0.42p
+ PS=1.54u PD=2.99u
M$781 VGND \$76 \$I4284 VGND sg13_lv_nmos L=0.13u W=0.55u AS=0.14875p AD=0.187p
+ PS=1.16u PD=1.78u
M$782 VGND \$I4284 B[8] VGND sg13_lv_nmos L=0.13u W=0.74u AS=0.14875p
+ AD=0.2886p PS=1.16u PD=2.26u
M$783 VPWR \$76 \$I4284 VPWR sg13_lv_pmos L=0.13u W=0.84u AS=0.2114p AD=0.2856p
+ PS=1.54u PD=2.36u
M$784 VPWR \$I4284 B[8] VPWR sg13_lv_pmos L=0.13u W=1.12u AS=0.2114p AD=0.42p
+ PS=1.54u PD=2.99u
M$785 VGND \$90 \$I4285 VGND sg13_lv_nmos L=0.13u W=0.55u AS=0.14875p AD=0.187p
+ PS=1.16u PD=1.78u
M$786 VGND \$I4285 \$145 VGND sg13_lv_nmos L=0.13u W=0.74u AS=0.14875p
+ AD=0.2886p PS=1.16u PD=2.26u
M$787 VPWR \$90 \$I4285 VPWR sg13_lv_pmos L=0.13u W=0.84u AS=0.2114p AD=0.2856p
+ PS=1.54u PD=2.36u
M$788 VPWR \$I4285 \$145 VPWR sg13_lv_pmos L=0.13u W=1.12u AS=0.2114p AD=0.42p
+ PS=1.54u PD=2.99u
M$789 VGND \$92 \$I4286 VGND sg13_lv_nmos L=0.13u W=0.55u AS=0.14875p AD=0.187p
+ PS=1.16u PD=1.78u
M$790 VGND \$I4286 D[4] VGND sg13_lv_nmos L=0.13u W=0.74u AS=0.14875p
+ AD=0.2886p PS=1.16u PD=2.26u
M$791 VPWR \$92 \$I4286 VPWR sg13_lv_pmos L=0.13u W=0.84u AS=0.2114p AD=0.2856p
+ PS=1.54u PD=2.36u
M$792 VPWR \$I4286 D[4] VPWR sg13_lv_pmos L=0.13u W=1.12u AS=0.2114p AD=0.42p
+ PS=1.54u PD=2.99u
M$793 VGND \$94 \$I4287 VGND sg13_lv_nmos L=0.13u W=0.55u AS=0.14875p AD=0.187p
+ PS=1.16u PD=1.78u
M$794 VGND \$I4287 D[0] VGND sg13_lv_nmos L=0.13u W=0.74u AS=0.14875p
+ AD=0.2886p PS=1.16u PD=2.26u
M$795 VPWR \$94 \$I4287 VPWR sg13_lv_pmos L=0.13u W=0.84u AS=0.2114p AD=0.2856p
+ PS=1.54u PD=2.36u
M$796 VPWR \$I4287 D[0] VPWR sg13_lv_pmos L=0.13u W=1.12u AS=0.2114p AD=0.42p
+ PS=1.54u PD=2.99u
M$797 VGND \$90 \$I4288 VGND sg13_lv_nmos L=0.13u W=0.55u AS=0.14875p AD=0.187p
+ PS=1.16u PD=1.78u
M$798 VGND \$I4288 sign VGND sg13_lv_nmos L=0.13u W=0.74u AS=0.14875p
+ AD=0.2886p PS=1.16u PD=2.26u
M$799 VPWR \$90 \$I4288 VPWR sg13_lv_pmos L=0.13u W=0.84u AS=0.2114p AD=0.2856p
+ PS=1.54u PD=2.36u
M$800 VPWR \$I4288 sign VPWR sg13_lv_pmos L=0.13u W=1.12u AS=0.2114p AD=0.42p
+ PS=1.54u PD=2.99u
M$801 VGND \$240 \$I4289 VGND sg13_lv_nmos L=0.13u W=0.55u AS=0.14875p
+ AD=0.187p PS=1.16u PD=1.78u
M$802 VGND \$I4289 D[9] VGND sg13_lv_nmos L=0.13u W=0.74u AS=0.14875p
+ AD=0.2886p PS=1.16u PD=2.26u
M$803 VPWR \$240 \$I4289 VPWR sg13_lv_pmos L=0.13u W=0.84u AS=0.2114p
+ AD=0.2856p PS=1.54u PD=2.36u
M$804 VPWR \$I4289 D[9] VPWR sg13_lv_pmos L=0.13u W=1.12u AS=0.2114p AD=0.42p
+ PS=1.54u PD=2.99u
M$805 VGND \$68 \$I4290 VGND sg13_lv_nmos L=0.13u W=0.55u AS=0.14875p AD=0.187p
+ PS=1.16u PD=1.78u
M$806 VGND \$I4290 B[11] VGND sg13_lv_nmos L=0.13u W=0.74u AS=0.14875p
+ AD=0.2886p PS=1.16u PD=2.26u
M$807 VPWR \$68 \$I4290 VPWR sg13_lv_pmos L=0.13u W=0.84u AS=0.2114p AD=0.2856p
+ PS=1.54u PD=2.36u
M$808 VPWR \$I4290 B[11] VPWR sg13_lv_pmos L=0.13u W=1.12u AS=0.2114p AD=0.42p
+ PS=1.54u PD=2.99u
M$809 VGND \$145 \$I4291 VGND sg13_lv_nmos L=0.13u W=0.55u AS=0.14875p
+ AD=0.187p PS=1.16u PD=1.78u
M$810 VGND \$I4291 BN[11] VGND sg13_lv_nmos L=0.13u W=0.74u AS=0.14875p
+ AD=0.2886p PS=1.16u PD=2.26u
M$811 VPWR \$145 \$I4291 VPWR sg13_lv_pmos L=0.13u W=0.84u AS=0.2114p
+ AD=0.2856p PS=1.54u PD=2.36u
M$812 VPWR \$I4291 BN[11] VPWR sg13_lv_pmos L=0.13u W=1.12u AS=0.2114p AD=0.42p
+ PS=1.54u PD=2.99u
M$813 VGND \$142 \$I4292 VGND sg13_lv_nmos L=0.13u W=0.55u AS=0.14875p
+ AD=0.187p PS=1.16u PD=1.78u
M$814 VGND \$I4292 D[8] VGND sg13_lv_nmos L=0.13u W=0.74u AS=0.14875p
+ AD=0.2886p PS=1.16u PD=2.26u
M$815 VPWR \$142 \$I4292 VPWR sg13_lv_pmos L=0.13u W=0.84u AS=0.2114p
+ AD=0.2856p PS=1.54u PD=2.36u
M$816 VPWR \$I4292 D[8] VPWR sg13_lv_pmos L=0.13u W=1.12u AS=0.2114p AD=0.42p
+ PS=1.54u PD=2.99u
M$817 VGND \$436 \$I4293 VGND sg13_lv_nmos L=0.13u W=0.55u AS=0.14875p
+ AD=0.187p PS=1.16u PD=1.78u
M$818 VGND \$I4293 BN[7] VGND sg13_lv_nmos L=0.13u W=0.74u AS=0.14875p
+ AD=0.2886p PS=1.16u PD=2.26u
M$819 VPWR \$436 \$I4293 VPWR sg13_lv_pmos L=0.13u W=0.84u AS=0.2114p
+ AD=0.2856p PS=1.54u PD=2.36u
M$820 VPWR \$I4293 BN[7] VPWR sg13_lv_pmos L=0.13u W=1.12u AS=0.2114p AD=0.42p
+ PS=1.54u PD=2.99u
M$821 VGND \$286 \$I4294 VGND sg13_lv_nmos L=0.13u W=0.55u AS=0.14875p
+ AD=0.187p PS=1.16u PD=1.78u
M$822 VGND \$I4294 B[4] VGND sg13_lv_nmos L=0.13u W=0.74u AS=0.14875p
+ AD=0.2886p PS=1.16u PD=2.26u
M$823 VPWR \$286 \$I4294 VPWR sg13_lv_pmos L=0.13u W=0.84u AS=0.2114p
+ AD=0.2856p PS=1.54u PD=2.36u
M$824 VPWR \$I4294 B[4] VPWR sg13_lv_pmos L=0.13u W=1.12u AS=0.2114p AD=0.42p
+ PS=1.54u PD=2.99u
M$825 VGND \$15 \$I4295 VGND sg13_lv_nmos L=0.13u W=0.55u AS=0.14875p AD=0.187p
+ PS=1.16u PD=1.78u
M$826 VGND \$I4295 \$I2838 VGND sg13_lv_nmos L=0.13u W=0.74u AS=0.14875p
+ AD=0.2886p PS=1.16u PD=2.26u
M$827 VPWR \$15 \$I4295 VPWR sg13_lv_pmos L=0.13u W=0.84u AS=0.2114p AD=0.2856p
+ PS=1.54u PD=2.36u
M$828 VPWR \$I4295 \$I2838 VPWR sg13_lv_pmos L=0.13u W=1.12u AS=0.2114p
+ AD=0.42p PS=1.54u PD=2.99u
M$829 VGND \$87 \$I4296 VGND sg13_lv_nmos L=0.13u W=0.55u AS=0.14875p AD=0.187p
+ PS=1.16u PD=1.78u
M$830 VGND \$I4296 \$202 VGND sg13_lv_nmos L=0.13u W=0.74u AS=0.14875p
+ AD=0.2886p PS=1.16u PD=2.26u
M$831 VPWR \$87 \$I4296 VPWR sg13_lv_pmos L=0.13u W=0.84u AS=0.2114p AD=0.2856p
+ PS=1.54u PD=2.36u
M$832 VPWR \$I4296 \$202 VPWR sg13_lv_pmos L=0.13u W=1.12u AS=0.2114p AD=0.42p
+ PS=1.54u PD=2.99u
M$833 VGND \$247 \$I4297 VGND sg13_lv_nmos L=0.13u W=0.55u AS=0.14875p
+ AD=0.187p PS=1.16u PD=1.78u
M$834 VGND \$I4297 B[2] VGND sg13_lv_nmos L=0.13u W=0.74u AS=0.14875p
+ AD=0.2886p PS=1.16u PD=2.26u
M$835 VPWR \$247 \$I4297 VPWR sg13_lv_pmos L=0.13u W=0.84u AS=0.2114p
+ AD=0.2856p PS=1.54u PD=2.36u
M$836 VPWR \$I4297 B[2] VPWR sg13_lv_pmos L=0.13u W=1.12u AS=0.2114p AD=0.42p
+ PS=1.54u PD=2.99u
M$837 VGND \$378 \$I4298 VGND sg13_lv_nmos L=0.13u W=0.55u AS=0.14875p
+ AD=0.187p PS=1.16u PD=1.78u
M$838 VGND \$I4298 BN[4] VGND sg13_lv_nmos L=0.13u W=0.74u AS=0.14875p
+ AD=0.2886p PS=1.16u PD=2.26u
M$839 VPWR \$378 \$I4298 VPWR sg13_lv_pmos L=0.13u W=0.84u AS=0.2114p
+ AD=0.2856p PS=1.54u PD=2.36u
M$840 VPWR \$I4298 BN[4] VPWR sg13_lv_pmos L=0.13u W=1.12u AS=0.2114p AD=0.42p
+ PS=1.54u PD=2.99u
M$841 VGND \$389 \$I4299 VGND sg13_lv_nmos L=0.13u W=0.55u AS=0.14875p
+ AD=0.187p PS=1.16u PD=1.78u
M$842 VGND \$I4299 D[5] VGND sg13_lv_nmos L=0.13u W=0.74u AS=0.14875p
+ AD=0.2886p PS=1.16u PD=2.26u
M$843 VPWR \$389 \$I4299 VPWR sg13_lv_pmos L=0.13u W=0.84u AS=0.2114p
+ AD=0.2856p PS=1.54u PD=2.36u
M$844 VPWR \$I4299 D[5] VPWR sg13_lv_pmos L=0.13u W=1.12u AS=0.2114p AD=0.42p
+ PS=1.54u PD=2.99u
M$845 VGND \$394 \$I4300 VGND sg13_lv_nmos L=0.13u W=0.55u AS=0.14875p
+ AD=0.187p PS=1.16u PD=1.78u
M$846 VGND \$I4300 \$370 VGND sg13_lv_nmos L=0.13u W=0.74u AS=0.14875p
+ AD=0.2886p PS=1.16u PD=2.26u
M$847 VPWR \$394 \$I4300 VPWR sg13_lv_pmos L=0.13u W=0.84u AS=0.2114p
+ AD=0.2856p PS=1.54u PD=2.36u
M$848 VPWR \$I4300 \$370 VPWR sg13_lv_pmos L=0.13u W=1.12u AS=0.2114p AD=0.42p
+ PS=1.54u PD=2.99u
M$849 VGND \$469 \$I4301 VGND sg13_lv_nmos L=0.13u W=0.55u AS=0.14875p
+ AD=0.187p PS=1.16u PD=1.78u
M$850 VGND \$I4301 B[1] VGND sg13_lv_nmos L=0.13u W=0.74u AS=0.14875p
+ AD=0.2886p PS=1.16u PD=2.26u
M$851 VPWR \$469 \$I4301 VPWR sg13_lv_pmos L=0.13u W=0.84u AS=0.2114p
+ AD=0.2856p PS=1.54u PD=2.36u
M$852 VPWR \$I4301 B[1] VPWR sg13_lv_pmos L=0.13u W=1.12u AS=0.2114p AD=0.42p
+ PS=1.54u PD=2.99u
M$853 VGND \$392 \$I4302 VGND sg13_lv_nmos L=0.13u W=0.55u AS=0.14875p
+ AD=0.187p PS=1.16u PD=1.78u
M$854 VGND \$I4302 \$470 VGND sg13_lv_nmos L=0.13u W=0.74u AS=0.14875p
+ AD=0.2886p PS=1.16u PD=2.26u
M$855 VPWR \$392 \$I4302 VPWR sg13_lv_pmos L=0.13u W=0.84u AS=0.2114p
+ AD=0.2856p PS=1.54u PD=2.36u
M$856 VPWR \$I4302 \$470 VPWR sg13_lv_pmos L=0.13u W=1.12u AS=0.2114p AD=0.42p
+ PS=1.54u PD=2.99u
M$857 VGND \$468 \$I4303 VGND sg13_lv_nmos L=0.13u W=0.55u AS=0.14875p
+ AD=0.187p PS=1.16u PD=1.78u
M$858 VGND \$I4303 D[2] VGND sg13_lv_nmos L=0.13u W=0.74u AS=0.14875p
+ AD=0.2886p PS=1.16u PD=2.26u
M$859 VPWR \$468 \$I4303 VPWR sg13_lv_pmos L=0.13u W=0.84u AS=0.2114p
+ AD=0.2856p PS=1.54u PD=2.36u
M$860 VPWR \$I4303 D[2] VPWR sg13_lv_pmos L=0.13u W=1.12u AS=0.2114p AD=0.42p
+ PS=1.54u PD=2.99u
M$861 VGND \$392 \$I4304 VGND sg13_lv_nmos L=0.13u W=0.55u AS=0.14875p
+ AD=0.187p PS=1.16u PD=1.78u
M$862 VGND \$I4304 \$544 VGND sg13_lv_nmos L=0.13u W=0.74u AS=0.14875p
+ AD=0.2886p PS=1.16u PD=2.26u
M$863 VPWR \$392 \$I4304 VPWR sg13_lv_pmos L=0.13u W=0.84u AS=0.2114p
+ AD=0.2856p PS=1.54u PD=2.36u
M$864 VPWR \$I4304 \$544 VPWR sg13_lv_pmos L=0.13u W=1.12u AS=0.2114p AD=0.42p
+ PS=1.54u PD=2.99u
M$865 VGND \$585 \$I4305 VGND sg13_lv_nmos L=0.13u W=0.55u AS=0.14875p
+ AD=0.187p PS=1.16u PD=1.78u
M$866 VGND \$I4305 BN[1] VGND sg13_lv_nmos L=0.13u W=0.74u AS=0.14875p
+ AD=0.2886p PS=1.16u PD=2.26u
M$867 VPWR \$585 \$I4305 VPWR sg13_lv_pmos L=0.13u W=0.84u AS=0.2114p
+ AD=0.2856p PS=1.54u PD=2.36u
M$868 VPWR \$I4305 BN[1] VPWR sg13_lv_pmos L=0.13u W=1.12u AS=0.2114p AD=0.42p
+ PS=1.54u PD=2.99u
M$869 VGND \$526 \$I4306 VGND sg13_lv_nmos L=0.13u W=0.55u AS=0.14875p
+ AD=0.187p PS=1.16u PD=1.78u
M$870 VGND \$I4306 \$491 VGND sg13_lv_nmos L=0.13u W=0.74u AS=0.14875p
+ AD=0.2886p PS=1.16u PD=2.26u
M$871 VPWR \$526 \$I4306 VPWR sg13_lv_pmos L=0.13u W=0.84u AS=0.2114p
+ AD=0.2856p PS=1.54u PD=2.36u
M$872 VPWR \$I4306 \$491 VPWR sg13_lv_pmos L=0.13u W=1.12u AS=0.2114p AD=0.42p
+ PS=1.54u PD=2.99u
M$873 VGND \$741 \$I4307 VGND sg13_lv_nmos L=0.13u W=0.55u AS=0.14875p
+ AD=0.187p PS=1.16u PD=1.78u
M$874 VGND \$I4307 B[9] VGND sg13_lv_nmos L=0.13u W=0.74u AS=0.14875p
+ AD=0.2886p PS=1.16u PD=2.26u
M$875 VPWR \$741 \$I4307 VPWR sg13_lv_pmos L=0.13u W=0.84u AS=0.2114p
+ AD=0.2856p PS=1.54u PD=2.36u
M$876 VPWR \$I4307 B[9] VPWR sg13_lv_pmos L=0.13u W=1.12u AS=0.2114p AD=0.42p
+ PS=1.54u PD=2.99u
M$877 VGND \$827 \$I4308 VGND sg13_lv_nmos L=0.13u W=0.55u AS=0.14875p
+ AD=0.187p PS=1.16u PD=1.78u
M$878 VGND \$I4308 D[10] VGND sg13_lv_nmos L=0.13u W=0.74u AS=0.14875p
+ AD=0.2886p PS=1.16u PD=2.26u
M$879 VPWR \$827 \$I4308 VPWR sg13_lv_pmos L=0.13u W=0.84u AS=0.2114p
+ AD=0.2856p PS=1.54u PD=2.36u
M$880 VPWR \$I4308 D[10] VPWR sg13_lv_pmos L=0.13u W=1.12u AS=0.2114p AD=0.42p
+ PS=1.54u PD=2.99u
M$881 VGND \$641 \$I4309 VGND sg13_lv_nmos L=0.13u W=0.55u AS=0.14875p
+ AD=0.187p PS=1.16u PD=1.78u
M$882 VGND \$I4309 BN[9] VGND sg13_lv_nmos L=0.13u W=0.74u AS=0.14875p
+ AD=0.2886p PS=1.16u PD=2.26u
M$883 VPWR \$641 \$I4309 VPWR sg13_lv_pmos L=0.13u W=0.84u AS=0.2114p
+ AD=0.2856p PS=1.54u PD=2.36u
M$884 VPWR \$I4309 BN[9] VPWR sg13_lv_pmos L=0.13u W=1.12u AS=0.2114p AD=0.42p
+ PS=1.54u PD=2.99u
M$885 VGND \$722 \$I4310 VGND sg13_lv_nmos L=0.13u W=0.55u AS=0.14875p
+ AD=0.187p PS=1.16u PD=1.78u
M$886 VGND \$I4310 D[3] VGND sg13_lv_nmos L=0.13u W=0.74u AS=0.14875p
+ AD=0.2886p PS=1.16u PD=2.26u
M$887 VPWR \$722 \$I4310 VPWR sg13_lv_pmos L=0.13u W=0.84u AS=0.2114p
+ AD=0.2856p PS=1.54u PD=2.36u
M$888 VPWR \$I4310 D[3] VPWR sg13_lv_pmos L=0.13u W=1.12u AS=0.2114p AD=0.42p
+ PS=1.54u PD=2.99u
M$889 VGND \$587 \$I4311 VGND sg13_lv_nmos L=0.13u W=0.55u AS=0.14875p
+ AD=0.187p PS=1.16u PD=1.78u
M$890 VGND \$I4311 \$I2820 VGND sg13_lv_nmos L=0.13u W=0.74u AS=0.14875p
+ AD=0.2886p PS=1.16u PD=2.26u
M$891 VPWR \$587 \$I4311 VPWR sg13_lv_pmos L=0.13u W=0.84u AS=0.2114p
+ AD=0.2856p PS=1.54u PD=2.36u
M$892 VPWR \$I4311 \$I2820 VPWR sg13_lv_pmos L=0.13u W=1.12u AS=0.2114p
+ AD=0.42p PS=1.54u PD=2.99u
M$893 VGND \$655 \$I4312 VGND sg13_lv_nmos L=0.13u W=0.55u AS=0.14875p
+ AD=0.187p PS=1.16u PD=1.78u
M$894 VGND \$I4312 BN[2] VGND sg13_lv_nmos L=0.13u W=0.74u AS=0.14875p
+ AD=0.2886p PS=1.16u PD=2.26u
M$895 VPWR \$655 \$I4312 VPWR sg13_lv_pmos L=0.13u W=0.84u AS=0.2114p
+ AD=0.2856p PS=1.54u PD=2.36u
M$896 VPWR \$I4312 BN[2] VPWR sg13_lv_pmos L=0.13u W=1.12u AS=0.2114p AD=0.42p
+ PS=1.54u PD=2.99u
M$897 VGND \$825 \$I4313 VGND sg13_lv_nmos L=0.13u W=0.55u AS=0.14875p
+ AD=0.187p PS=1.16u PD=1.78u
M$898 VGND \$I4313 BN[6] VGND sg13_lv_nmos L=0.13u W=0.74u AS=0.14875p
+ AD=0.2886p PS=1.16u PD=2.26u
M$899 VPWR \$825 \$I4313 VPWR sg13_lv_pmos L=0.13u W=0.84u AS=0.2114p
+ AD=0.2856p PS=1.54u PD=2.36u
M$900 VPWR \$I4313 BN[6] VPWR sg13_lv_pmos L=0.13u W=1.12u AS=0.2114p AD=0.42p
+ PS=1.54u PD=2.99u
M$901 VGND \$608 \$I4314 VGND sg13_lv_nmos L=0.13u W=0.55u AS=0.14875p
+ AD=0.187p PS=1.16u PD=1.78u
M$902 VGND \$I4314 \$I2842 VGND sg13_lv_nmos L=0.13u W=0.74u AS=0.14875p
+ AD=0.2886p PS=1.16u PD=2.26u
M$903 VPWR \$608 \$I4314 VPWR sg13_lv_pmos L=0.13u W=0.84u AS=0.2114p
+ AD=0.2856p PS=1.54u PD=2.36u
M$904 VPWR \$I4314 \$I2842 VPWR sg13_lv_pmos L=0.13u W=1.12u AS=0.2114p
+ AD=0.42p PS=1.54u PD=2.99u
M$905 VGND \$460 \$I4315 VGND sg13_lv_nmos L=0.13u W=0.55u AS=0.14875p
+ AD=0.187p PS=1.16u PD=1.78u
M$906 VGND \$I4315 B[7] VGND sg13_lv_nmos L=0.13u W=0.74u AS=0.14875p
+ AD=0.2886p PS=1.16u PD=2.26u
M$907 VPWR \$460 \$I4315 VPWR sg13_lv_pmos L=0.13u W=0.84u AS=0.2114p
+ AD=0.2856p PS=1.54u PD=2.36u
M$908 VPWR \$I4315 B[7] VPWR sg13_lv_pmos L=0.13u W=1.12u AS=0.2114p AD=0.42p
+ PS=1.54u PD=2.99u
M$909 VGND \$861 \$I4316 VGND sg13_lv_nmos L=0.13u W=0.55u AS=0.14875p
+ AD=0.187p PS=1.16u PD=1.78u
M$910 VGND \$I4316 D[7] VGND sg13_lv_nmos L=0.13u W=0.74u AS=0.14875p
+ AD=0.2886p PS=1.16u PD=2.26u
M$911 VPWR \$861 \$I4316 VPWR sg13_lv_pmos L=0.13u W=0.84u AS=0.2114p
+ AD=0.2856p PS=1.54u PD=2.36u
M$912 VPWR \$I4316 D[7] VPWR sg13_lv_pmos L=0.13u W=1.12u AS=0.2114p AD=0.42p
+ PS=1.54u PD=2.99u
M$913 VGND \$818 \$I4317 VGND sg13_lv_nmos L=0.13u W=0.55u AS=0.14875p
+ AD=0.187p PS=1.16u PD=1.78u
M$914 VGND \$I4317 BN[5] VGND sg13_lv_nmos L=0.13u W=0.74u AS=0.14875p
+ AD=0.2886p PS=1.16u PD=2.26u
M$915 VPWR \$818 \$I4317 VPWR sg13_lv_pmos L=0.13u W=0.84u AS=0.2114p
+ AD=0.2856p PS=1.54u PD=2.36u
M$916 VPWR \$I4317 BN[5] VPWR sg13_lv_pmos L=0.13u W=1.12u AS=0.2114p AD=0.42p
+ PS=1.54u PD=2.99u
M$917 VGND \$893 \$I4318 VGND sg13_lv_nmos L=0.13u W=0.55u AS=0.14875p
+ AD=0.187p PS=1.16u PD=1.78u
M$918 VGND \$I4318 D[6] VGND sg13_lv_nmos L=0.13u W=0.74u AS=0.14875p
+ AD=0.2886p PS=1.16u PD=2.26u
M$919 VPWR \$893 \$I4318 VPWR sg13_lv_pmos L=0.13u W=0.84u AS=0.2114p
+ AD=0.2856p PS=1.54u PD=2.36u
M$920 VPWR \$I4318 D[6] VPWR sg13_lv_pmos L=0.13u W=1.12u AS=0.2114p AD=0.42p
+ PS=1.54u PD=2.99u
M$921 VGND \$817 \$I4319 VGND sg13_lv_nmos L=0.13u W=0.55u AS=0.14875p
+ AD=0.187p PS=1.16u PD=1.78u
M$922 VGND \$I4319 B[5] VGND sg13_lv_nmos L=0.13u W=0.74u AS=0.14875p
+ AD=0.2886p PS=1.16u PD=2.26u
M$923 VPWR \$817 \$I4319 VPWR sg13_lv_pmos L=0.13u W=0.84u AS=0.2114p
+ AD=0.2856p PS=1.54u PD=2.36u
M$924 VPWR \$I4319 B[5] VPWR sg13_lv_pmos L=0.13u W=1.12u AS=0.2114p AD=0.42p
+ PS=1.54u PD=2.99u
M$925 VGND \$859 \$I4320 VGND sg13_lv_nmos L=0.13u W=0.55u AS=0.14875p
+ AD=0.187p PS=1.16u PD=1.78u
M$926 VGND \$I4320 B[10] VGND sg13_lv_nmos L=0.13u W=0.74u AS=0.14875p
+ AD=0.2886p PS=1.16u PD=2.26u
M$927 VPWR \$859 \$I4320 VPWR sg13_lv_pmos L=0.13u W=0.84u AS=0.2114p
+ AD=0.2856p PS=1.54u PD=2.36u
M$928 VPWR \$I4320 B[10] VPWR sg13_lv_pmos L=0.13u W=1.12u AS=0.2114p AD=0.42p
+ PS=1.54u PD=2.99u
M$929 VGND \$808 \$I4321 VGND sg13_lv_nmos L=0.13u W=0.55u AS=0.14875p
+ AD=0.187p PS=1.16u PD=1.78u
M$930 VGND \$I4321 BN[10] VGND sg13_lv_nmos L=0.13u W=0.74u AS=0.14875p
+ AD=0.2886p PS=1.16u PD=2.26u
M$931 VPWR \$808 \$I4321 VPWR sg13_lv_pmos L=0.13u W=0.84u AS=0.2114p
+ AD=0.2856p PS=1.54u PD=2.36u
M$932 VPWR \$I4321 BN[10] VPWR sg13_lv_pmos L=0.13u W=1.12u AS=0.2114p AD=0.42p
+ PS=1.54u PD=2.99u
M$933 VGND \$847 \$I4322 VGND sg13_lv_nmos L=0.13u W=0.55u AS=0.14875p
+ AD=0.187p PS=1.16u PD=1.78u
M$934 VGND \$I4322 D[11] VGND sg13_lv_nmos L=0.13u W=0.74u AS=0.14875p
+ AD=0.2886p PS=1.16u PD=2.26u
M$935 VPWR \$847 \$I4322 VPWR sg13_lv_pmos L=0.13u W=0.84u AS=0.2114p
+ AD=0.2856p PS=1.54u PD=2.36u
M$936 VPWR \$I4322 D[11] VPWR sg13_lv_pmos L=0.13u W=1.12u AS=0.2114p AD=0.42p
+ PS=1.54u PD=2.99u
M$937 VGND \$869 \$I4323 VGND sg13_lv_nmos L=0.13u W=0.55u AS=0.14875p
+ AD=0.187p PS=1.16u PD=1.78u
M$938 VGND \$I4323 B[6] VGND sg13_lv_nmos L=0.13u W=0.74u AS=0.14875p
+ AD=0.2886p PS=1.16u PD=2.26u
M$939 VPWR \$869 \$I4323 VPWR sg13_lv_pmos L=0.13u W=0.84u AS=0.2114p
+ AD=0.2856p PS=1.54u PD=2.36u
M$940 VPWR \$I4323 B[6] VPWR sg13_lv_pmos L=0.13u W=1.12u AS=0.2114p AD=0.42p
+ PS=1.54u PD=2.99u
M$941 VGND \$198 \$I4324 VGND sg13_lv_nmos L=0.13u W=0.55u AS=0.18575p
+ AD=0.187p PS=1.26u PD=1.78u
M$942 VGND \$136 \$I4326 VGND sg13_lv_nmos L=0.13u W=0.74u AS=0.18575p
+ AD=0.1406p PS=1.26u PD=1.12u
M$943 \$I4326 \$59 \$I4325 VGND sg13_lv_nmos L=0.13u W=0.74u AS=0.1406p
+ AD=0.1406p PS=1.12u PD=1.12u
M$944 \$I4325 \$I4324 \$121 VGND sg13_lv_nmos L=0.13u W=0.74u AS=0.1406p
+ AD=0.3404p PS=1.12u PD=2.4u
M$945 \$I4324 \$198 VPWR VPWR sg13_lv_pmos L=0.13u W=0.84u AS=0.2856p
+ AD=0.2198p PS=2.36u PD=1.53u
M$946 VPWR \$136 \$121 VPWR sg13_lv_pmos L=0.13u W=1.12u AS=0.2198p AD=0.2128p
+ PS=1.53u PD=1.5u
M$947 \$121 \$59 VPWR VPWR sg13_lv_pmos L=0.13u W=1.12u AS=0.2128p AD=0.2128p
+ PS=1.5u PD=1.5u
M$948 VPWR \$I4324 \$121 VPWR sg13_lv_pmos L=0.13u W=1.12u AS=0.2128p
+ AD=0.3808p PS=1.5u PD=2.92u
M$949 VGND \$44 \$I4327 VGND sg13_lv_nmos L=0.13u W=0.55u AS=0.18575p AD=0.187p
+ PS=1.26u PD=1.78u
M$950 VGND \$230 \$I4329 VGND sg13_lv_nmos L=0.13u W=0.74u AS=0.18575p
+ AD=0.1406p PS=1.26u PD=1.12u
M$951 \$I4329 \$354 \$I4328 VGND sg13_lv_nmos L=0.13u W=0.74u AS=0.1406p
+ AD=0.1406p PS=1.12u PD=1.12u
M$952 \$I4328 \$I4327 \$352 VGND sg13_lv_nmos L=0.13u W=0.74u AS=0.1406p
+ AD=0.3404p PS=1.12u PD=2.4u
M$953 \$I4327 \$44 VPWR VPWR sg13_lv_pmos L=0.13u W=0.84u AS=0.2856p AD=0.2198p
+ PS=2.36u PD=1.53u
M$954 VPWR \$230 \$352 VPWR sg13_lv_pmos L=0.13u W=1.12u AS=0.2198p AD=0.2128p
+ PS=1.53u PD=1.5u
M$955 \$352 \$354 VPWR VPWR sg13_lv_pmos L=0.13u W=1.12u AS=0.2128p AD=0.2128p
+ PS=1.5u PD=1.5u
M$956 VPWR \$I4327 \$352 VPWR sg13_lv_pmos L=0.13u W=1.12u AS=0.2128p
+ AD=0.3808p PS=1.5u PD=2.92u
M$957 \$I4330 \$195 VGND VGND sg13_lv_nmos L=0.15u W=0.74u AS=0.2516p
+ AD=0.1406p PS=2.16u PD=1.12u
M$958 VGND \$268 \$I4330 VGND sg13_lv_nmos L=0.15u W=0.74u AS=0.1406p
+ AD=0.1406p PS=1.12u PD=1.12u
M$959 \$I4330 \$217 \$181 VGND sg13_lv_nmos L=0.15u W=0.74u AS=0.1406p
+ AD=0.2516p PS=1.12u PD=2.16u
M$960 VPWR \$195 \$I4331 VPWR sg13_lv_pmos L=0.15u W=1.12u AS=0.3808p
+ AD=0.2128p PS=2.92u PD=1.5u
M$961 \$I4331 \$268 \$181 VPWR sg13_lv_pmos L=0.15u W=1.12u AS=0.2128p
+ AD=0.2128p PS=1.5u PD=1.5u
M$962 \$181 \$217 VPWR VPWR sg13_lv_pmos L=0.15u W=1.12u AS=0.2128p AD=0.3808p
+ PS=1.5u PD=2.92u
M$963 \$I4332 \$228 VGND VGND sg13_lv_nmos L=0.15u W=0.74u AS=0.2516p
+ AD=0.1406p PS=2.16u PD=1.12u
M$964 VGND \$198 \$I4332 VGND sg13_lv_nmos L=0.15u W=0.74u AS=0.1406p
+ AD=0.1406p PS=1.12u PD=1.12u
M$965 \$I4332 \$232 \$17 VGND sg13_lv_nmos L=0.15u W=0.74u AS=0.1406p
+ AD=0.2516p PS=1.12u PD=2.16u
M$966 VPWR \$228 \$I4333 VPWR sg13_lv_pmos L=0.15u W=1.12u AS=0.3808p
+ AD=0.2128p PS=2.92u PD=1.5u
M$967 \$I4333 \$198 \$17 VPWR sg13_lv_pmos L=0.15u W=1.12u AS=0.2128p
+ AD=0.2128p PS=1.5u PD=1.5u
M$968 \$17 \$232 VPWR VPWR sg13_lv_pmos L=0.15u W=1.12u AS=0.2128p AD=0.3808p
+ PS=1.5u PD=2.92u
M$969 \$I4334 \$195 VGND VGND sg13_lv_nmos L=0.15u W=0.74u AS=0.2516p
+ AD=0.1406p PS=2.16u PD=1.12u
M$970 VGND \$198 \$I4334 VGND sg13_lv_nmos L=0.15u W=0.74u AS=0.1406p
+ AD=0.1406p PS=1.12u PD=1.12u
M$971 \$I4334 \$43 \$354 VGND sg13_lv_nmos L=0.15u W=0.74u AS=0.1406p
+ AD=0.2516p PS=1.12u PD=2.16u
M$972 VPWR \$195 \$I4335 VPWR sg13_lv_pmos L=0.15u W=1.12u AS=0.3808p
+ AD=0.2128p PS=2.92u PD=1.5u
M$973 \$I4335 \$198 \$354 VPWR sg13_lv_pmos L=0.15u W=1.12u AS=0.2128p
+ AD=0.2128p PS=1.5u PD=1.5u
M$974 \$354 \$43 VPWR VPWR sg13_lv_pmos L=0.15u W=1.12u AS=0.2128p AD=0.3808p
+ PS=1.5u PD=2.92u
M$975 VGND \$16 \$152 VGND sg13_lv_nmos L=0.13u W=0.74u AS=0.2516p AD=0.1406p
+ PS=2.16u PD=1.12u
M$976 \$152 \$121 \$I4337 VGND sg13_lv_nmos L=0.13u W=0.74u AS=0.1406p
+ AD=0.1406p PS=1.12u PD=1.12u
M$977 \$I4337 \$17 VGND VGND sg13_lv_nmos L=0.13u W=0.74u AS=0.1406p AD=0.2516p
+ PS=1.12u PD=2.16u
M$978 \$152 \$16 \$I4336 VPWR sg13_lv_pmos L=0.13u W=1.12u AS=0.3808p
+ AD=0.2128p PS=2.92u PD=1.5u
M$979 \$I4336 \$121 VPWR VPWR sg13_lv_pmos L=0.13u W=1.12u AS=0.2128p
+ AD=0.2128p PS=1.5u PD=1.5u
M$980 VPWR \$17 \$I4336 VPWR sg13_lv_pmos L=0.13u W=1.12u AS=0.2128p AD=0.3808p
+ PS=1.5u PD=2.92u
M$981 VGND \$16 \$217 VGND sg13_lv_nmos L=0.13u W=0.74u AS=0.2516p AD=0.1406p
+ PS=2.16u PD=1.12u
M$982 \$217 \$195 \$I4339 VGND sg13_lv_nmos L=0.13u W=0.74u AS=0.1406p
+ AD=0.1406p PS=1.12u PD=1.12u
M$983 \$I4339 \$198 VGND VGND sg13_lv_nmos L=0.13u W=0.74u AS=0.1406p
+ AD=0.2516p PS=1.12u PD=2.16u
M$984 \$217 \$16 \$I4338 VPWR sg13_lv_pmos L=0.13u W=1.12u AS=0.3808p
+ AD=0.2128p PS=2.92u PD=1.5u
M$985 \$I4338 \$195 VPWR VPWR sg13_lv_pmos L=0.13u W=1.12u AS=0.2128p
+ AD=0.2128p PS=1.5u PD=1.5u
M$986 VPWR \$198 \$I4338 VPWR sg13_lv_pmos L=0.13u W=1.12u AS=0.2128p
+ AD=0.3808p PS=1.5u PD=2.92u
M$987 VGND \$20 \$I4342 VGND sg13_lv_nmos L=0.13u W=0.64u AS=0.2272p AD=0.0784p
+ PS=1.99u PD=0.885u
M$988 \$I4342 \$28 \$I4341 VGND sg13_lv_nmos L=0.13u W=0.64u AS=0.0784p
+ AD=0.2176p PS=0.885u PD=1.96u
M$989 VGND \$20 \$I4340 VGND sg13_lv_nmos L=0.13u W=0.74u AS=0.1898p AD=0.2516p
+ PS=1.36u PD=2.16u
M$990 VGND \$28 \$I4340 VGND sg13_lv_nmos L=0.13u W=0.74u AS=0.1898p AD=0.1406p
+ PS=1.36u PD=1.12u
M$991 \$I4340 \$I4341 \$198 VGND sg13_lv_nmos L=0.13u W=0.74u AS=0.1406p
+ AD=0.2516p PS=1.12u PD=2.16u
M$992 VPWR \$20 \$I4341 VPWR sg13_lv_pmos L=0.13u W=0.84u AS=0.4536p AD=0.1596p
+ PS=2.76u PD=1.22u
M$993 VPWR \$28 \$I4341 VPWR sg13_lv_pmos L=0.13u W=0.84u AS=0.2891p AD=0.1596p
+ PS=1.695u PD=1.22u
M$994 VPWR \$20 \$I4343 VPWR sg13_lv_pmos L=0.13u W=1.12u AS=0.2891p AD=0.1428p
+ PS=1.695u PD=1.375u
M$995 \$I4343 \$28 \$198 VPWR sg13_lv_pmos L=0.13u W=1.12u AS=0.1428p
+ AD=0.2408p PS=1.375u PD=1.55u
M$996 \$198 \$I4341 VPWR VPWR sg13_lv_pmos L=0.13u W=1.12u AS=0.2408p
+ AD=0.3808p PS=1.55u PD=2.92u
M$997 VGND \$68 \$I4344 VGND sg13_lv_nmos L=0.13u W=0.55u AS=0.18945p AD=0.187p
+ PS=1.27u PD=1.78u
M$998 VGND \$68 \$I4346 VGND sg13_lv_nmos L=0.13u W=0.74u AS=0.18945p
+ AD=0.13135p PS=1.27u PD=1.095u
M$999 \$I4346 \$19 \$I4345 VGND sg13_lv_nmos L=0.13u W=0.74u AS=0.13135p
+ AD=0.1628p PS=1.095u PD=1.18u
M$1000 \$I4345 \$34 \$I4347 VGND sg13_lv_nmos L=0.13u W=0.74u AS=0.1628p
+ AD=0.3367p PS=1.18u PD=1.65u
M$1001 \$I4347 \$I4344 VGND VGND sg13_lv_nmos L=0.13u W=0.74u AS=0.3367p
+ AD=0.148p PS=1.65u PD=1.14u
M$1002 VGND \$I4345 \$83 VGND sg13_lv_nmos L=0.13u W=0.74u AS=0.148p AD=0.4033p
+ PS=1.14u PD=2.57u
M$1003 \$I4344 \$68 VPWR VPWR sg13_lv_pmos L=0.13u W=0.84u AS=0.2856p AD=0.253p
+ PS=2.36u PD=1.53u
M$1004 VPWR \$68 \$I4348 VPWR sg13_lv_pmos L=0.13u W=1u AS=0.253p AD=0.3325p
+ PS=1.53u PD=1.665u
M$1005 \$I4348 \$34 \$I4345 VPWR sg13_lv_pmos L=0.13u W=1u AS=0.3325p
+ AD=0.2225p PS=1.665u PD=1.445u
M$1006 \$I4345 \$19 \$I4349 VPWR sg13_lv_pmos L=0.13u W=1u AS=0.2225p
+ AD=0.2975p PS=1.445u PD=1.595u
M$1007 \$I4349 \$I4344 VPWR VPWR sg13_lv_pmos L=0.13u W=1u AS=0.2975p
+ AD=0.2198p PS=1.595u PD=1.52u
M$1008 VPWR \$I4345 \$83 VPWR sg13_lv_pmos L=0.13u W=1.12u AS=0.2198p
+ AD=0.6048p PS=1.52u PD=3.32u
M$1009 VGND \$68 \$I4350 VGND sg13_lv_nmos L=0.13u W=0.55u AS=0.18945p
+ AD=0.187p PS=1.27u PD=1.78u
M$1010 VGND \$68 \$I4352 VGND sg13_lv_nmos L=0.13u W=0.74u AS=0.18945p
+ AD=0.13135p PS=1.27u PD=1.095u
M$1011 \$I4352 \$76 \$I4351 VGND sg13_lv_nmos L=0.13u W=0.74u AS=0.13135p
+ AD=0.1628p PS=1.095u PD=1.18u
M$1012 \$I4351 \$75 \$I4353 VGND sg13_lv_nmos L=0.13u W=0.74u AS=0.1628p
+ AD=0.3367p PS=1.18u PD=1.65u
M$1013 \$I4353 \$I4350 VGND VGND sg13_lv_nmos L=0.13u W=0.74u AS=0.3367p
+ AD=0.148p PS=1.65u PD=1.14u
M$1014 VGND \$I4351 \$240 VGND sg13_lv_nmos L=0.13u W=0.74u AS=0.148p
+ AD=0.4033p PS=1.14u PD=2.57u
M$1015 \$I4350 \$68 VPWR VPWR sg13_lv_pmos L=0.13u W=0.84u AS=0.2856p AD=0.253p
+ PS=2.36u PD=1.53u
M$1016 VPWR \$68 \$I4354 VPWR sg13_lv_pmos L=0.13u W=1u AS=0.253p AD=0.3325p
+ PS=1.53u PD=1.665u
M$1017 \$I4354 \$75 \$I4351 VPWR sg13_lv_pmos L=0.13u W=1u AS=0.3325p
+ AD=0.2225p PS=1.665u PD=1.445u
M$1018 \$I4351 \$76 \$I4355 VPWR sg13_lv_pmos L=0.13u W=1u AS=0.2225p
+ AD=0.2975p PS=1.445u PD=1.595u
M$1019 \$I4355 \$I4350 VPWR VPWR sg13_lv_pmos L=0.13u W=1u AS=0.2975p
+ AD=0.2198p PS=1.595u PD=1.52u
M$1020 VPWR \$I4351 \$240 VPWR sg13_lv_pmos L=0.13u W=1.12u AS=0.2198p
+ AD=0.6048p PS=1.52u PD=3.32u
M$1021 VGND \$68 \$I4356 VGND sg13_lv_nmos L=0.13u W=0.55u AS=0.18945p
+ AD=0.187p PS=1.27u PD=1.78u
M$1022 VGND \$68 \$I4358 VGND sg13_lv_nmos L=0.13u W=0.74u AS=0.18945p
+ AD=0.13135p PS=1.27u PD=1.095u
M$1023 \$I4358 \$286 \$I4357 VGND sg13_lv_nmos L=0.13u W=0.74u AS=0.13135p
+ AD=0.1628p PS=1.095u PD=1.18u
M$1024 \$I4357 \$378 \$I4359 VGND sg13_lv_nmos L=0.13u W=0.74u AS=0.1628p
+ AD=0.3367p PS=1.18u PD=1.65u
M$1025 \$I4359 \$I4356 VGND VGND sg13_lv_nmos L=0.13u W=0.74u AS=0.3367p
+ AD=0.148p PS=1.65u PD=1.14u
M$1026 VGND \$I4357 \$389 VGND sg13_lv_nmos L=0.13u W=0.74u AS=0.148p
+ AD=0.4033p PS=1.14u PD=2.57u
M$1027 \$I4356 \$68 VPWR VPWR sg13_lv_pmos L=0.13u W=0.84u AS=0.2856p AD=0.253p
+ PS=2.36u PD=1.53u
M$1028 VPWR \$68 \$I4360 VPWR sg13_lv_pmos L=0.13u W=1u AS=0.253p AD=0.3325p
+ PS=1.53u PD=1.665u
M$1029 \$I4360 \$378 \$I4357 VPWR sg13_lv_pmos L=0.13u W=1u AS=0.3325p
+ AD=0.2225p PS=1.665u PD=1.445u
M$1030 \$I4357 \$286 \$I4361 VPWR sg13_lv_pmos L=0.13u W=1u AS=0.2225p
+ AD=0.2975p PS=1.445u PD=1.595u
M$1031 \$I4361 \$I4356 VPWR VPWR sg13_lv_pmos L=0.13u W=1u AS=0.2975p
+ AD=0.2198p PS=1.595u PD=1.52u
M$1032 VPWR \$I4357 \$389 VPWR sg13_lv_pmos L=0.13u W=1.12u AS=0.2198p
+ AD=0.6048p PS=1.52u PD=3.32u
M$1033 VGND \$64 \$I4362 VGND sg13_lv_nmos L=0.13u W=0.55u AS=0.18945p
+ AD=0.187p PS=1.27u PD=1.78u
M$1034 VGND \$64 \$I4364 VGND sg13_lv_nmos L=0.13u W=0.74u AS=0.18945p
+ AD=0.13135p PS=1.27u PD=1.095u
M$1035 \$I4364 \$35 \$I4363 VGND sg13_lv_nmos L=0.13u W=0.74u AS=0.13135p
+ AD=0.1628p PS=1.095u PD=1.18u
M$1036 \$I4363 \$65 \$I4365 VGND sg13_lv_nmos L=0.13u W=0.74u AS=0.1628p
+ AD=0.3367p PS=1.18u PD=1.65u
M$1037 \$I4365 \$I4362 VGND VGND sg13_lv_nmos L=0.13u W=0.74u AS=0.3367p
+ AD=0.148p PS=1.65u PD=1.14u
M$1038 VGND \$I4363 \$92 VGND sg13_lv_nmos L=0.13u W=0.74u AS=0.148p AD=0.4033p
+ PS=1.14u PD=2.57u
M$1039 \$I4362 \$64 VPWR VPWR sg13_lv_pmos L=0.13u W=0.84u AS=0.2856p AD=0.253p
+ PS=2.36u PD=1.53u
M$1040 VPWR \$64 \$I4366 VPWR sg13_lv_pmos L=0.13u W=1u AS=0.253p AD=0.3325p
+ PS=1.53u PD=1.665u
M$1041 \$I4366 \$65 \$I4363 VPWR sg13_lv_pmos L=0.13u W=1u AS=0.3325p
+ AD=0.2225p PS=1.665u PD=1.445u
M$1042 \$I4363 \$35 \$I4367 VPWR sg13_lv_pmos L=0.13u W=1u AS=0.2225p
+ AD=0.2975p PS=1.445u PD=1.595u
M$1043 \$I4367 \$I4362 VPWR VPWR sg13_lv_pmos L=0.13u W=1u AS=0.2975p
+ AD=0.2198p PS=1.595u PD=1.52u
M$1044 VPWR \$I4363 \$92 VPWR sg13_lv_pmos L=0.13u W=1.12u AS=0.2198p
+ AD=0.6048p PS=1.52u PD=3.32u
M$1045 VGND \$64 \$I4368 VGND sg13_lv_nmos L=0.13u W=0.55u AS=0.18945p
+ AD=0.187p PS=1.27u PD=1.78u
M$1046 VGND \$64 \$I4370 VGND sg13_lv_nmos L=0.13u W=0.74u AS=0.18945p
+ AD=0.13135p PS=1.27u PD=1.095u
M$1047 \$I4370 \$460 \$I4369 VGND sg13_lv_nmos L=0.13u W=0.74u AS=0.13135p
+ AD=0.1628p PS=1.095u PD=1.18u
M$1048 \$I4369 \$436 \$I4371 VGND sg13_lv_nmos L=0.13u W=0.74u AS=0.1628p
+ AD=0.3367p PS=1.18u PD=1.65u
M$1049 \$I4371 \$I4368 VGND VGND sg13_lv_nmos L=0.13u W=0.74u AS=0.3367p
+ AD=0.148p PS=1.65u PD=1.14u
M$1050 VGND \$I4369 \$142 VGND sg13_lv_nmos L=0.13u W=0.74u AS=0.148p
+ AD=0.4033p PS=1.14u PD=2.57u
M$1051 \$I4368 \$64 VPWR VPWR sg13_lv_pmos L=0.13u W=0.84u AS=0.2856p AD=0.253p
+ PS=2.36u PD=1.53u
M$1052 VPWR \$64 \$I4372 VPWR sg13_lv_pmos L=0.13u W=1u AS=0.253p AD=0.3325p
+ PS=1.53u PD=1.665u
M$1053 \$I4372 \$436 \$I4369 VPWR sg13_lv_pmos L=0.13u W=1u AS=0.3325p
+ AD=0.2225p PS=1.665u PD=1.445u
M$1054 \$I4369 \$460 \$I4373 VPWR sg13_lv_pmos L=0.13u W=1u AS=0.2225p
+ AD=0.2975p PS=1.445u PD=1.595u
M$1055 \$I4373 \$I4368 VPWR VPWR sg13_lv_pmos L=0.13u W=1u AS=0.2975p
+ AD=0.2198p PS=1.595u PD=1.52u
M$1056 VPWR \$I4369 \$142 VPWR sg13_lv_pmos L=0.13u W=1.12u AS=0.2198p
+ AD=0.6048p PS=1.52u PD=3.32u
M$1057 VGND \$68 \$I4374 VGND sg13_lv_nmos L=0.13u W=0.55u AS=0.18945p
+ AD=0.187p PS=1.27u PD=1.78u
M$1058 VGND \$68 \$I4376 VGND sg13_lv_nmos L=0.13u W=0.74u AS=0.18945p
+ AD=0.13135p PS=1.27u PD=1.095u
M$1059 \$I4376 \$469 \$I4375 VGND sg13_lv_nmos L=0.13u W=0.74u AS=0.13135p
+ AD=0.1628p PS=1.095u PD=1.18u
M$1060 \$I4375 \$585 \$I4377 VGND sg13_lv_nmos L=0.13u W=0.74u AS=0.1628p
+ AD=0.3367p PS=1.18u PD=1.65u
M$1061 \$I4377 \$I4374 VGND VGND sg13_lv_nmos L=0.13u W=0.74u AS=0.3367p
+ AD=0.148p PS=1.65u PD=1.14u
M$1062 VGND \$I4375 \$468 VGND sg13_lv_nmos L=0.13u W=0.74u AS=0.148p
+ AD=0.4033p PS=1.14u PD=2.57u
M$1063 \$I4374 \$68 VPWR VPWR sg13_lv_pmos L=0.13u W=0.84u AS=0.2856p AD=0.253p
+ PS=2.36u PD=1.53u
M$1064 VPWR \$68 \$I4378 VPWR sg13_lv_pmos L=0.13u W=1u AS=0.253p AD=0.3325p
+ PS=1.53u PD=1.665u
M$1065 \$I4378 \$585 \$I4375 VPWR sg13_lv_pmos L=0.13u W=1u AS=0.3325p
+ AD=0.2225p PS=1.665u PD=1.445u
M$1066 \$I4375 \$469 \$I4379 VPWR sg13_lv_pmos L=0.13u W=1u AS=0.2225p
+ AD=0.2975p PS=1.445u PD=1.595u
M$1067 \$I4379 \$I4374 VPWR VPWR sg13_lv_pmos L=0.13u W=1u AS=0.2975p
+ AD=0.2198p PS=1.595u PD=1.52u
M$1068 VPWR \$I4375 \$468 VPWR sg13_lv_pmos L=0.13u W=1.12u AS=0.2198p
+ AD=0.6048p PS=1.52u PD=3.32u
M$1069 VGND \$64 \$I4380 VGND sg13_lv_nmos L=0.13u W=0.55u AS=0.18945p
+ AD=0.187p PS=1.27u PD=1.78u
M$1070 VGND \$64 \$I4382 VGND sg13_lv_nmos L=0.13u W=0.74u AS=0.18945p
+ AD=0.13135p PS=1.27u PD=1.095u
M$1071 \$I4382 \$247 \$I4381 VGND sg13_lv_nmos L=0.13u W=0.74u AS=0.13135p
+ AD=0.1628p PS=1.095u PD=1.18u
M$1072 \$I4381 \$655 \$I4383 VGND sg13_lv_nmos L=0.13u W=0.74u AS=0.1628p
+ AD=0.3367p PS=1.18u PD=1.65u
M$1073 \$I4383 \$I4380 VGND VGND sg13_lv_nmos L=0.13u W=0.74u AS=0.3367p
+ AD=0.148p PS=1.65u PD=1.14u
M$1074 VGND \$I4381 \$722 VGND sg13_lv_nmos L=0.13u W=0.74u AS=0.148p
+ AD=0.4033p PS=1.14u PD=2.57u
M$1075 \$I4380 \$64 VPWR VPWR sg13_lv_pmos L=0.13u W=0.84u AS=0.2856p AD=0.253p
+ PS=2.36u PD=1.53u
M$1076 VPWR \$64 \$I4384 VPWR sg13_lv_pmos L=0.13u W=1u AS=0.253p AD=0.3325p
+ PS=1.53u PD=1.665u
M$1077 \$I4384 \$655 \$I4381 VPWR sg13_lv_pmos L=0.13u W=1u AS=0.3325p
+ AD=0.2225p PS=1.665u PD=1.445u
M$1078 \$I4381 \$247 \$I4385 VPWR sg13_lv_pmos L=0.13u W=1u AS=0.2225p
+ AD=0.2975p PS=1.445u PD=1.595u
M$1079 \$I4385 \$I4380 VPWR VPWR sg13_lv_pmos L=0.13u W=1u AS=0.2975p
+ AD=0.2198p PS=1.595u PD=1.52u
M$1080 VPWR \$I4381 \$722 VPWR sg13_lv_pmos L=0.13u W=1.12u AS=0.2198p
+ AD=0.6048p PS=1.52u PD=3.32u
M$1081 VGND \$64 \$I4386 VGND sg13_lv_nmos L=0.13u W=0.55u AS=0.18945p
+ AD=0.187p PS=1.27u PD=1.78u
M$1082 VGND \$64 \$I4388 VGND sg13_lv_nmos L=0.13u W=0.74u AS=0.18945p
+ AD=0.13135p PS=1.27u PD=1.095u
M$1083 \$I4388 \$859 \$I4387 VGND sg13_lv_nmos L=0.13u W=0.74u AS=0.13135p
+ AD=0.1628p PS=1.095u PD=1.18u
M$1084 \$I4387 \$808 \$I4389 VGND sg13_lv_nmos L=0.13u W=0.74u AS=0.1628p
+ AD=0.3367p PS=1.18u PD=1.65u
M$1085 \$I4389 \$I4386 VGND VGND sg13_lv_nmos L=0.13u W=0.74u AS=0.3367p
+ AD=0.148p PS=1.65u PD=1.14u
M$1086 VGND \$I4387 \$847 VGND sg13_lv_nmos L=0.13u W=0.74u AS=0.148p
+ AD=0.4033p PS=1.14u PD=2.57u
M$1087 \$I4386 \$64 VPWR VPWR sg13_lv_pmos L=0.13u W=0.84u AS=0.2856p AD=0.253p
+ PS=2.36u PD=1.53u
M$1088 VPWR \$64 \$I4390 VPWR sg13_lv_pmos L=0.13u W=1u AS=0.253p AD=0.3325p
+ PS=1.53u PD=1.665u
M$1089 \$I4390 \$808 \$I4387 VPWR sg13_lv_pmos L=0.13u W=1u AS=0.3325p
+ AD=0.2225p PS=1.665u PD=1.445u
M$1090 \$I4387 \$859 \$I4391 VPWR sg13_lv_pmos L=0.13u W=1u AS=0.2225p
+ AD=0.2975p PS=1.445u PD=1.595u
M$1091 \$I4391 \$I4386 VPWR VPWR sg13_lv_pmos L=0.13u W=1u AS=0.2975p
+ AD=0.2198p PS=1.595u PD=1.52u
M$1092 VPWR \$I4387 \$847 VPWR sg13_lv_pmos L=0.13u W=1.12u AS=0.2198p
+ AD=0.6048p PS=1.52u PD=3.32u
M$1093 VGND \$68 \$I4392 VGND sg13_lv_nmos L=0.13u W=0.55u AS=0.18945p
+ AD=0.187p PS=1.27u PD=1.78u
M$1094 VGND \$68 \$I4394 VGND sg13_lv_nmos L=0.13u W=0.74u AS=0.18945p
+ AD=0.13135p PS=1.27u PD=1.095u
M$1095 \$I4394 \$741 \$I4393 VGND sg13_lv_nmos L=0.13u W=0.74u AS=0.13135p
+ AD=0.1628p PS=1.095u PD=1.18u
M$1096 \$I4393 \$641 \$I4395 VGND sg13_lv_nmos L=0.13u W=0.74u AS=0.1628p
+ AD=0.3367p PS=1.18u PD=1.65u
M$1097 \$I4395 \$I4392 VGND VGND sg13_lv_nmos L=0.13u W=0.74u AS=0.3367p
+ AD=0.148p PS=1.65u PD=1.14u
M$1098 VGND \$I4393 \$827 VGND sg13_lv_nmos L=0.13u W=0.74u AS=0.148p
+ AD=0.4033p PS=1.14u PD=2.57u
M$1099 \$I4392 \$68 VPWR VPWR sg13_lv_pmos L=0.13u W=0.84u AS=0.2856p AD=0.253p
+ PS=2.36u PD=1.53u
M$1100 VPWR \$68 \$I4396 VPWR sg13_lv_pmos L=0.13u W=1u AS=0.253p AD=0.3325p
+ PS=1.53u PD=1.665u
M$1101 \$I4396 \$641 \$I4393 VPWR sg13_lv_pmos L=0.13u W=1u AS=0.3325p
+ AD=0.2225p PS=1.665u PD=1.445u
M$1102 \$I4393 \$741 \$I4397 VPWR sg13_lv_pmos L=0.13u W=1u AS=0.2225p
+ AD=0.2975p PS=1.445u PD=1.595u
M$1103 \$I4397 \$I4392 VPWR VPWR sg13_lv_pmos L=0.13u W=1u AS=0.2975p
+ AD=0.2198p PS=1.595u PD=1.52u
M$1104 VPWR \$I4393 \$827 VPWR sg13_lv_pmos L=0.13u W=1.12u AS=0.2198p
+ AD=0.6048p PS=1.52u PD=3.32u
M$1105 VGND \$68 \$I4398 VGND sg13_lv_nmos L=0.13u W=0.55u AS=0.18945p
+ AD=0.187p PS=1.27u PD=1.78u
M$1106 VGND \$68 \$I4400 VGND sg13_lv_nmos L=0.13u W=0.74u AS=0.18945p
+ AD=0.13135p PS=1.27u PD=1.095u
M$1107 \$I4400 \$817 \$I4399 VGND sg13_lv_nmos L=0.13u W=0.74u AS=0.13135p
+ AD=0.1628p PS=1.095u PD=1.18u
M$1108 \$I4399 \$818 \$I4401 VGND sg13_lv_nmos L=0.13u W=0.74u AS=0.1628p
+ AD=0.3367p PS=1.18u PD=1.65u
M$1109 \$I4401 \$I4398 VGND VGND sg13_lv_nmos L=0.13u W=0.74u AS=0.3367p
+ AD=0.148p PS=1.65u PD=1.14u
M$1110 VGND \$I4399 \$893 VGND sg13_lv_nmos L=0.13u W=0.74u AS=0.148p
+ AD=0.4033p PS=1.14u PD=2.57u
M$1111 \$I4398 \$68 VPWR VPWR sg13_lv_pmos L=0.13u W=0.84u AS=0.2856p AD=0.253p
+ PS=2.36u PD=1.53u
M$1112 VPWR \$68 \$I4402 VPWR sg13_lv_pmos L=0.13u W=1u AS=0.253p AD=0.3325p
+ PS=1.53u PD=1.665u
M$1113 \$I4402 \$818 \$I4399 VPWR sg13_lv_pmos L=0.13u W=1u AS=0.3325p
+ AD=0.2225p PS=1.665u PD=1.445u
M$1114 \$I4399 \$817 \$I4403 VPWR sg13_lv_pmos L=0.13u W=1u AS=0.2225p
+ AD=0.2975p PS=1.445u PD=1.595u
M$1115 \$I4403 \$I4398 VPWR VPWR sg13_lv_pmos L=0.13u W=1u AS=0.2975p
+ AD=0.2198p PS=1.595u PD=1.52u
M$1116 VPWR \$I4399 \$893 VPWR sg13_lv_pmos L=0.13u W=1.12u AS=0.2198p
+ AD=0.6048p PS=1.52u PD=3.32u
M$1117 VGND \$64 \$I4404 VGND sg13_lv_nmos L=0.13u W=0.55u AS=0.18945p
+ AD=0.187p PS=1.27u PD=1.78u
M$1118 VGND \$64 \$I4406 VGND sg13_lv_nmos L=0.13u W=0.74u AS=0.18945p
+ AD=0.13135p PS=1.27u PD=1.095u
M$1119 \$I4406 \$869 \$I4405 VGND sg13_lv_nmos L=0.13u W=0.74u AS=0.13135p
+ AD=0.1628p PS=1.095u PD=1.18u
M$1120 \$I4405 \$825 \$I4407 VGND sg13_lv_nmos L=0.13u W=0.74u AS=0.1628p
+ AD=0.3367p PS=1.18u PD=1.65u
M$1121 \$I4407 \$I4404 VGND VGND sg13_lv_nmos L=0.13u W=0.74u AS=0.3367p
+ AD=0.148p PS=1.65u PD=1.14u
M$1122 VGND \$I4405 \$861 VGND sg13_lv_nmos L=0.13u W=0.74u AS=0.148p
+ AD=0.4033p PS=1.14u PD=2.57u
M$1123 \$I4404 \$64 VPWR VPWR sg13_lv_pmos L=0.13u W=0.84u AS=0.2856p AD=0.253p
+ PS=2.36u PD=1.53u
M$1124 VPWR \$64 \$I4408 VPWR sg13_lv_pmos L=0.13u W=1u AS=0.253p AD=0.3325p
+ PS=1.53u PD=1.665u
M$1125 \$I4408 \$825 \$I4405 VPWR sg13_lv_pmos L=0.13u W=1u AS=0.3325p
+ AD=0.2225p PS=1.665u PD=1.445u
M$1126 \$I4405 \$869 \$I4409 VPWR sg13_lv_pmos L=0.13u W=1u AS=0.2225p
+ AD=0.2975p PS=1.445u PD=1.595u
M$1127 \$I4409 \$I4404 VPWR VPWR sg13_lv_pmos L=0.13u W=1u AS=0.2975p
+ AD=0.2198p PS=1.595u PD=1.52u
M$1128 VPWR \$I4405 \$861 VPWR sg13_lv_pmos L=0.13u W=1.12u AS=0.2198p
+ AD=0.6048p PS=1.52u PD=3.32u
M$1129 VGND \$63 \$I4412 VGND sg13_lv_nmos L=0.13u W=0.74u AS=0.2516p
+ AD=0.1406p PS=2.16u PD=1.12u
M$1130 \$I4412 \$370 \$I4411 VGND sg13_lv_nmos L=0.13u W=0.74u AS=0.1406p
+ AD=0.1406p PS=1.12u PD=1.12u
M$1131 \$I4411 \$202 \$I4410 VGND sg13_lv_nmos L=0.13u W=0.74u AS=0.1406p
+ AD=0.1406p PS=1.12u PD=1.12u
M$1132 \$I4410 \$43 \$300 VGND sg13_lv_nmos L=0.13u W=0.74u AS=0.1406p
+ AD=0.2516p PS=1.12u PD=2.16u
M$1133 VPWR \$63 \$300 VPWR sg13_lv_pmos L=0.13u W=1.12u AS=0.3808p AD=0.2128p
+ PS=2.92u PD=1.5u
M$1134 \$300 \$370 VPWR VPWR sg13_lv_pmos L=0.13u W=1.12u AS=0.2128p AD=0.2128p
+ PS=1.5u PD=1.5u
M$1135 VPWR \$202 \$300 VPWR sg13_lv_pmos L=0.13u W=1.12u AS=0.2128p AD=0.2128p
+ PS=1.5u PD=1.5u
M$1136 \$300 \$43 VPWR VPWR sg13_lv_pmos L=0.13u W=1.12u AS=0.2128p AD=0.3808p
+ PS=1.5u PD=2.92u
M$1137 VGND \$59 \$I4415 VGND sg13_lv_nmos L=0.13u W=0.74u AS=0.2516p
+ AD=0.1406p PS=2.16u PD=1.12u
M$1138 \$I4415 \$174 \$I4414 VGND sg13_lv_nmos L=0.13u W=0.74u AS=0.1406p
+ AD=0.1406p PS=1.12u PD=1.12u
M$1139 \$I4414 \$202 \$I4413 VGND sg13_lv_nmos L=0.13u W=0.74u AS=0.1406p
+ AD=0.1406p PS=1.12u PD=1.12u
M$1140 \$I4413 \$43 \$88 VGND sg13_lv_nmos L=0.13u W=0.74u AS=0.1406p
+ AD=0.2516p PS=1.12u PD=2.16u
M$1141 VPWR \$59 \$88 VPWR sg13_lv_pmos L=0.13u W=1.12u AS=0.3808p AD=0.2128p
+ PS=2.92u PD=1.5u
M$1142 \$88 \$174 VPWR VPWR sg13_lv_pmos L=0.13u W=1.12u AS=0.2128p AD=0.2128p
+ PS=1.5u PD=1.5u
M$1143 VPWR \$202 \$88 VPWR sg13_lv_pmos L=0.13u W=1.12u AS=0.2128p AD=0.2128p
+ PS=1.5u PD=1.5u
M$1144 \$88 \$43 VPWR VPWR sg13_lv_pmos L=0.13u W=1.12u AS=0.2128p AD=0.3808p
+ PS=1.5u PD=2.92u
M$1145 VGND \$491 \$I4418 VGND sg13_lv_nmos L=0.13u W=0.74u AS=0.2516p
+ AD=0.1406p PS=2.16u PD=1.12u
M$1146 \$I4418 \$431 \$I4417 VGND sg13_lv_nmos L=0.13u W=0.74u AS=0.1406p
+ AD=0.1406p PS=1.12u PD=1.12u
M$1147 \$I4417 \$202 \$I4416 VGND sg13_lv_nmos L=0.13u W=0.74u AS=0.1406p
+ AD=0.1406p PS=1.12u PD=1.12u
M$1148 \$I4416 \$397 \$259 VGND sg13_lv_nmos L=0.13u W=0.74u AS=0.1406p
+ AD=0.2516p PS=1.12u PD=2.16u
M$1149 VPWR \$491 \$259 VPWR sg13_lv_pmos L=0.13u W=1.12u AS=0.3808p AD=0.2128p
+ PS=2.92u PD=1.5u
M$1150 \$259 \$431 VPWR VPWR sg13_lv_pmos L=0.13u W=1.12u AS=0.2128p AD=0.2128p
+ PS=1.5u PD=1.5u
M$1151 VPWR \$202 \$259 VPWR sg13_lv_pmos L=0.13u W=1.12u AS=0.2128p AD=0.2128p
+ PS=1.5u PD=1.5u
M$1152 \$259 \$397 VPWR VPWR sg13_lv_pmos L=0.13u W=1.12u AS=0.2128p AD=0.3808p
+ PS=1.5u PD=2.92u
M$1153 VGND \$58 \$I4421 VGND sg13_lv_nmos L=0.13u W=0.74u AS=0.2516p
+ AD=0.1406p PS=2.16u PD=1.12u
M$1154 \$I4421 \$335 \$I4420 VGND sg13_lv_nmos L=0.13u W=0.74u AS=0.1406p
+ AD=0.1406p PS=1.12u PD=1.12u
M$1155 \$I4420 \$195 \$I4419 VGND sg13_lv_nmos L=0.13u W=0.74u AS=0.1406p
+ AD=0.1406p PS=1.12u PD=1.12u
M$1156 \$I4419 \$43 \$543 VGND sg13_lv_nmos L=0.13u W=0.74u AS=0.1406p
+ AD=0.2516p PS=1.12u PD=2.16u
M$1157 VPWR \$58 \$543 VPWR sg13_lv_pmos L=0.13u W=1.12u AS=0.3808p AD=0.2128p
+ PS=2.92u PD=1.5u
M$1158 \$543 \$335 VPWR VPWR sg13_lv_pmos L=0.13u W=1.12u AS=0.2128p AD=0.2128p
+ PS=1.5u PD=1.5u
M$1159 VPWR \$195 \$543 VPWR sg13_lv_pmos L=0.13u W=1.12u AS=0.2128p AD=0.2128p
+ PS=1.5u PD=1.5u
M$1160 \$543 \$43 VPWR VPWR sg13_lv_pmos L=0.13u W=1.12u AS=0.2128p AD=0.3808p
+ PS=1.5u PD=2.92u
M$1161 VGND \$298 \$I4424 VGND sg13_lv_nmos L=0.13u W=0.74u AS=0.2516p
+ AD=0.1406p PS=2.16u PD=1.12u
M$1162 \$I4424 \$370 \$I4423 VGND sg13_lv_nmos L=0.13u W=0.74u AS=0.1406p
+ AD=0.1406p PS=1.12u PD=1.12u
M$1163 \$I4423 \$202 \$I4422 VGND sg13_lv_nmos L=0.13u W=0.74u AS=0.1406p
+ AD=0.1406p PS=1.12u PD=1.12u
M$1164 \$I4422 \$397 \$487 VGND sg13_lv_nmos L=0.13u W=0.74u AS=0.1406p
+ AD=0.2516p PS=1.12u PD=2.16u
M$1165 VPWR \$298 \$487 VPWR sg13_lv_pmos L=0.13u W=1.12u AS=0.3808p AD=0.2128p
+ PS=2.92u PD=1.5u
M$1166 \$487 \$370 VPWR VPWR sg13_lv_pmos L=0.13u W=1.12u AS=0.2128p AD=0.2128p
+ PS=1.5u PD=1.5u
M$1167 VPWR \$202 \$487 VPWR sg13_lv_pmos L=0.13u W=1.12u AS=0.2128p AD=0.2128p
+ PS=1.5u PD=1.5u
M$1168 \$487 \$397 VPWR VPWR sg13_lv_pmos L=0.13u W=1.12u AS=0.2128p AD=0.3808p
+ PS=1.5u PD=2.92u
M$1169 VGND \$491 \$I4427 VGND sg13_lv_nmos L=0.13u W=0.74u AS=0.2516p
+ AD=0.1406p PS=2.16u PD=1.12u
M$1170 \$I4427 \$298 \$I4426 VGND sg13_lv_nmos L=0.13u W=0.74u AS=0.1406p
+ AD=0.1406p PS=1.12u PD=1.12u
M$1171 \$I4426 \$202 \$I4425 VGND sg13_lv_nmos L=0.13u W=0.74u AS=0.1406p
+ AD=0.1406p PS=1.12u PD=1.12u
M$1172 \$I4425 \$397 \$569 VGND sg13_lv_nmos L=0.13u W=0.74u AS=0.1406p
+ AD=0.2516p PS=1.12u PD=2.16u
M$1173 VPWR \$491 \$569 VPWR sg13_lv_pmos L=0.13u W=1.12u AS=0.3808p AD=0.2128p
+ PS=2.92u PD=1.5u
M$1174 \$569 \$298 VPWR VPWR sg13_lv_pmos L=0.13u W=1.12u AS=0.2128p AD=0.2128p
+ PS=1.5u PD=1.5u
M$1175 VPWR \$202 \$569 VPWR sg13_lv_pmos L=0.13u W=1.12u AS=0.2128p AD=0.2128p
+ PS=1.5u PD=1.5u
M$1176 \$569 \$397 VPWR VPWR sg13_lv_pmos L=0.13u W=1.12u AS=0.2128p AD=0.3808p
+ PS=1.5u PD=2.92u
M$1177 VGND \$165 \$I4428 VGND sg13_lv_nmos L=0.13u W=0.64u AS=0.1448p
+ AD=0.2176p PS=1.13u PD=1.96u
M$1178 VGND \$I4428 \$298 VGND sg13_lv_nmos L=0.13u W=1.44u AS=0.2816p
+ AD=0.3816p PS=2.23u PD=3.22u
M$1179 \$298 \$18 VGND VGND sg13_lv_nmos L=0.13u W=1.44u AS=0.2736p AD=0.2736p
+ PS=2.2u PD=2.2u
M$1182 \$I4428 \$165 VPWR VPWR sg13_lv_pmos L=0.13u W=1u AS=0.34p AD=0.2254p
+ PS=2.68u PD=1.53u
M$1183 VPWR \$I4428 \$I4429 VPWR sg13_lv_pmos L=0.13u W=2.24u AS=0.4382p
+ AD=0.5936p PS=3.03u PD=4.42u
M$1184 \$I4429 \$18 \$298 VPWR sg13_lv_pmos L=0.13u W=2.24u AS=0.4256p
+ AD=0.4256p PS=3u PD=3u
M$1187 VGND \$84 \$I4430 VGND sg13_lv_nmos L=0.13u W=0.64u AS=0.1448p
+ AD=0.2176p PS=1.13u PD=1.96u
M$1188 VGND \$I4430 \$335 VGND sg13_lv_nmos L=0.13u W=1.44u AS=0.2816p
+ AD=0.3816p PS=2.23u PD=3.22u
M$1189 \$335 \$232 VGND VGND sg13_lv_nmos L=0.13u W=1.44u AS=0.2736p AD=0.2736p
+ PS=2.2u PD=2.2u
M$1192 \$I4430 \$84 VPWR VPWR sg13_lv_pmos L=0.13u W=1u AS=0.34p AD=0.2254p
+ PS=2.68u PD=1.53u
M$1193 VPWR \$I4430 \$I4431 VPWR sg13_lv_pmos L=0.13u W=2.24u AS=0.4382p
+ AD=0.5936p PS=3.03u PD=4.42u
M$1194 \$I4431 \$232 \$335 VPWR sg13_lv_pmos L=0.13u W=2.24u AS=0.4256p
+ AD=0.4256p PS=3u PD=3u
M$1197 VGND \$195 \$I4432 VGND sg13_lv_nmos L=0.13u W=0.64u AS=0.1448p
+ AD=0.2176p PS=1.13u PD=1.96u
M$1198 VGND \$I4432 \$538 VGND sg13_lv_nmos L=0.13u W=1.44u AS=0.2816p
+ AD=0.3816p PS=2.23u PD=3.22u
M$1199 \$538 \$43 VGND VGND sg13_lv_nmos L=0.13u W=1.44u AS=0.2736p AD=0.2736p
+ PS=2.2u PD=2.2u
M$1202 \$I4432 \$195 VPWR VPWR sg13_lv_pmos L=0.13u W=1u AS=0.34p AD=0.2254p
+ PS=2.68u PD=1.53u
M$1203 VPWR \$I4432 \$I4433 VPWR sg13_lv_pmos L=0.13u W=2.24u AS=0.4382p
+ AD=0.5936p PS=3.03u PD=4.42u
M$1204 \$I4433 \$43 \$538 VPWR sg13_lv_pmos L=0.13u W=2.24u AS=0.4256p
+ AD=0.4256p PS=3u PD=3u
M$1207 VGND \$43 \$I4434 VGND sg13_lv_nmos L=0.13u W=0.64u AS=0.1448p
+ AD=0.2176p PS=1.13u PD=1.96u
M$1208 VGND \$I4434 \$450 VGND sg13_lv_nmos L=0.13u W=1.44u AS=0.2816p
+ AD=0.3816p PS=2.23u PD=3.22u
M$1209 \$450 \$195 VGND VGND sg13_lv_nmos L=0.13u W=1.44u AS=0.2736p AD=0.2736p
+ PS=2.2u PD=2.2u
M$1212 \$I4434 \$43 VPWR VPWR sg13_lv_pmos L=0.13u W=1u AS=0.34p AD=0.2254p
+ PS=2.68u PD=1.53u
M$1213 VPWR \$I4434 \$I4435 VPWR sg13_lv_pmos L=0.13u W=2.24u AS=0.4382p
+ AD=0.5936p PS=3.03u PD=4.42u
M$1214 \$I4435 \$195 \$450 VPWR sg13_lv_pmos L=0.13u W=2.24u AS=0.4256p
+ AD=0.4256p PS=3u PD=3u
M$1217 \$14 \$I4436 VGND VGND sg13_lv_nmos L=0.13u W=0.74u AS=0.2351p
+ AD=0.15745p PS=2.16u PD=1.175u
M$1218 VGND \$16 \$I4436 VGND sg13_lv_nmos L=0.13u W=0.64u AS=0.15745p
+ AD=0.1216p PS=1.175u PD=1.02u
M$1219 \$I4436 \$103 \$I4438 VGND sg13_lv_nmos L=0.13u W=0.64u AS=0.1216p
+ AD=0.0816p PS=1.02u PD=0.895u
M$1220 \$I4438 \$33 VGND VGND sg13_lv_nmos L=0.13u W=0.64u AS=0.0816p
+ AD=0.2176p PS=0.895u PD=1.96u
M$1221 \$I4436 \$16 \$I4437 VPWR sg13_lv_pmos L=0.13u W=1u AS=0.35p AD=0.2125p
+ PS=2.7u PD=1.425u
M$1222 \$I4437 \$103 VPWR VPWR sg13_lv_pmos L=0.13u W=1u AS=0.2125p AD=0.19p
+ PS=1.425u PD=1.38u
M$1223 VPWR \$33 \$I4437 VPWR sg13_lv_pmos L=0.13u W=1u AS=0.19p AD=0.34p
+ PS=1.38u PD=2.68u
M$1224 \$14 \$I4436 VPWR VPWR sg13_lv_pmos L=0.13u W=1.12u AS=0.3808p
+ AD=0.3808p PS=2.92u PD=2.92u
M$1225 \$130 \$I4439 VGND VGND sg13_lv_nmos L=0.13u W=0.74u AS=0.2351p
+ AD=0.15745p PS=2.16u PD=1.175u
M$1226 VGND \$44 \$I4439 VGND sg13_lv_nmos L=0.13u W=0.64u AS=0.15745p
+ AD=0.1216p PS=1.175u PD=1.02u
M$1227 \$I4439 \$45 \$I4441 VGND sg13_lv_nmos L=0.13u W=0.64u AS=0.1216p
+ AD=0.0816p PS=1.02u PD=0.895u
M$1228 \$I4441 \$88 VGND VGND sg13_lv_nmos L=0.13u W=0.64u AS=0.0816p
+ AD=0.2176p PS=0.895u PD=1.96u
M$1229 \$I4439 \$44 \$I4440 VPWR sg13_lv_pmos L=0.13u W=1u AS=0.35p AD=0.2125p
+ PS=2.7u PD=1.425u
M$1230 \$I4440 \$45 VPWR VPWR sg13_lv_pmos L=0.13u W=1u AS=0.2125p AD=0.19p
+ PS=1.425u PD=1.38u
M$1231 VPWR \$88 \$I4440 VPWR sg13_lv_pmos L=0.13u W=1u AS=0.19p AD=0.34p
+ PS=1.38u PD=2.68u
M$1232 \$130 \$I4439 VPWR VPWR sg13_lv_pmos L=0.13u W=1.12u AS=0.3808p
+ AD=0.3808p PS=2.92u PD=2.92u
M$1233 \$81 \$I4442 VGND VGND sg13_lv_nmos L=0.13u W=0.74u AS=0.2351p
+ AD=0.15745p PS=2.16u PD=1.175u
M$1234 VGND \$16 \$I4442 VGND sg13_lv_nmos L=0.13u W=0.64u AS=0.15745p
+ AD=0.1216p PS=1.175u PD=1.02u
M$1235 \$I4442 \$51 \$I4444 VGND sg13_lv_nmos L=0.13u W=0.64u AS=0.1216p
+ AD=0.0816p PS=1.02u PD=0.895u
M$1236 \$I4444 \$39 VGND VGND sg13_lv_nmos L=0.13u W=0.64u AS=0.0816p
+ AD=0.2176p PS=0.895u PD=1.96u
M$1237 \$I4442 \$16 \$I4443 VPWR sg13_lv_pmos L=0.13u W=1u AS=0.35p AD=0.2125p
+ PS=2.7u PD=1.425u
M$1238 \$I4443 \$51 VPWR VPWR sg13_lv_pmos L=0.13u W=1u AS=0.2125p AD=0.19p
+ PS=1.425u PD=1.38u
M$1239 VPWR \$39 \$I4443 VPWR sg13_lv_pmos L=0.13u W=1u AS=0.19p AD=0.34p
+ PS=1.38u PD=2.68u
M$1240 \$81 \$I4442 VPWR VPWR sg13_lv_pmos L=0.13u W=1.12u AS=0.3808p
+ AD=0.3808p PS=2.92u PD=2.92u
M$1241 \$70 \$I4445 VGND VGND sg13_lv_nmos L=0.13u W=0.74u AS=0.2351p
+ AD=0.15745p PS=2.16u PD=1.175u
M$1242 VGND \$16 \$I4445 VGND sg13_lv_nmos L=0.13u W=0.64u AS=0.15745p
+ AD=0.1216p PS=1.175u PD=1.02u
M$1243 \$I4445 \$114 \$I4447 VGND sg13_lv_nmos L=0.13u W=0.64u AS=0.1216p
+ AD=0.0816p PS=1.02u PD=0.895u
M$1244 \$I4447 \$40 VGND VGND sg13_lv_nmos L=0.13u W=0.64u AS=0.0816p
+ AD=0.2176p PS=0.895u PD=1.96u
M$1245 \$I4445 \$16 \$I4446 VPWR sg13_lv_pmos L=0.13u W=1u AS=0.35p AD=0.2125p
+ PS=2.7u PD=1.425u
M$1246 \$I4446 \$114 VPWR VPWR sg13_lv_pmos L=0.13u W=1u AS=0.2125p AD=0.19p
+ PS=1.425u PD=1.38u
M$1247 VPWR \$40 \$I4446 VPWR sg13_lv_pmos L=0.13u W=1u AS=0.19p AD=0.34p
+ PS=1.38u PD=2.68u
M$1248 \$70 \$I4445 VPWR VPWR sg13_lv_pmos L=0.13u W=1.12u AS=0.3808p
+ AD=0.3808p PS=2.92u PD=2.92u
M$1249 \$204 \$I4448 VGND VGND sg13_lv_nmos L=0.13u W=0.74u AS=0.2351p
+ AD=0.15745p PS=2.16u PD=1.175u
M$1250 VGND \$44 \$I4448 VGND sg13_lv_nmos L=0.13u W=0.64u AS=0.15745p
+ AD=0.1216p PS=1.175u PD=1.02u
M$1251 \$I4448 \$175 \$I4450 VGND sg13_lv_nmos L=0.13u W=0.64u AS=0.1216p
+ AD=0.0816p PS=1.02u PD=0.895u
M$1252 \$I4450 \$259 VGND VGND sg13_lv_nmos L=0.13u W=0.64u AS=0.0816p
+ AD=0.2176p PS=0.895u PD=1.96u
M$1253 \$I4448 \$44 \$I4449 VPWR sg13_lv_pmos L=0.13u W=1u AS=0.35p AD=0.2125p
+ PS=2.7u PD=1.425u
M$1254 \$I4449 \$175 VPWR VPWR sg13_lv_pmos L=0.13u W=1u AS=0.2125p AD=0.19p
+ PS=1.425u PD=1.38u
M$1255 VPWR \$259 \$I4449 VPWR sg13_lv_pmos L=0.13u W=1u AS=0.19p AD=0.34p
+ PS=1.38u PD=2.68u
M$1256 \$204 \$I4448 VPWR VPWR sg13_lv_pmos L=0.13u W=1.12u AS=0.3808p
+ AD=0.3808p PS=2.92u PD=2.92u
M$1257 \$42 \$I4451 VGND VGND sg13_lv_nmos L=0.13u W=0.74u AS=0.2351p
+ AD=0.15745p PS=2.16u PD=1.175u
M$1258 VGND \$16 \$I4451 VGND sg13_lv_nmos L=0.13u W=0.64u AS=0.15745p
+ AD=0.1216p PS=1.175u PD=1.02u
M$1259 \$I4451 \$84 \$I4453 VGND sg13_lv_nmos L=0.13u W=0.64u AS=0.1216p
+ AD=0.0816p PS=1.02u PD=0.895u
M$1260 \$I4453 \$121 VGND VGND sg13_lv_nmos L=0.13u W=0.64u AS=0.0816p
+ AD=0.2176p PS=0.895u PD=1.96u
M$1261 \$I4451 \$16 \$I4452 VPWR sg13_lv_pmos L=0.13u W=1u AS=0.35p AD=0.2125p
+ PS=2.7u PD=1.425u
M$1262 \$I4452 \$84 VPWR VPWR sg13_lv_pmos L=0.13u W=1u AS=0.2125p AD=0.19p
+ PS=1.425u PD=1.38u
M$1263 VPWR \$121 \$I4452 VPWR sg13_lv_pmos L=0.13u W=1u AS=0.19p AD=0.34p
+ PS=1.38u PD=2.68u
M$1264 \$42 \$I4451 VPWR VPWR sg13_lv_pmos L=0.13u W=1.12u AS=0.3808p
+ AD=0.3808p PS=2.92u PD=2.92u
M$1265 \$161 \$I4454 VGND VGND sg13_lv_nmos L=0.13u W=0.74u AS=0.2351p
+ AD=0.15745p PS=2.16u PD=1.175u
M$1266 VGND \$16 \$I4454 VGND sg13_lv_nmos L=0.13u W=0.64u AS=0.15745p
+ AD=0.1216p PS=1.175u PD=1.02u
M$1267 \$I4454 \$253 \$I4456 VGND sg13_lv_nmos L=0.13u W=0.64u AS=0.1216p
+ AD=0.0816p PS=1.02u PD=0.895u
M$1268 \$I4456 \$77 VGND VGND sg13_lv_nmos L=0.13u W=0.64u AS=0.0816p
+ AD=0.2176p PS=0.895u PD=1.96u
M$1269 \$I4454 \$16 \$I4455 VPWR sg13_lv_pmos L=0.13u W=1u AS=0.35p AD=0.2125p
+ PS=2.7u PD=1.425u
M$1270 \$I4455 \$253 VPWR VPWR sg13_lv_pmos L=0.13u W=1u AS=0.2125p AD=0.19p
+ PS=1.425u PD=1.38u
M$1271 VPWR \$77 \$I4455 VPWR sg13_lv_pmos L=0.13u W=1u AS=0.19p AD=0.34p
+ PS=1.38u PD=2.68u
M$1272 \$161 \$I4454 VPWR VPWR sg13_lv_pmos L=0.13u W=1.12u AS=0.3808p
+ AD=0.3808p PS=2.92u PD=2.92u
M$1273 \$268 \$I4457 VGND VGND sg13_lv_nmos L=0.13u W=0.74u AS=0.2351p
+ AD=0.15745p PS=2.16u PD=1.175u
M$1274 VGND \$198 \$I4457 VGND sg13_lv_nmos L=0.13u W=0.64u AS=0.15745p
+ AD=0.1216p PS=1.175u PD=1.02u
M$1275 \$I4457 \$136 \$I4459 VGND sg13_lv_nmos L=0.13u W=0.64u AS=0.1216p
+ AD=0.0816p PS=1.02u PD=0.895u
M$1276 \$I4459 \$63 VGND VGND sg13_lv_nmos L=0.13u W=0.64u AS=0.0816p
+ AD=0.2176p PS=0.895u PD=1.96u
M$1277 \$I4457 \$198 \$I4458 VPWR sg13_lv_pmos L=0.13u W=1u AS=0.35p AD=0.2125p
+ PS=2.7u PD=1.425u
M$1278 \$I4458 \$136 VPWR VPWR sg13_lv_pmos L=0.13u W=1u AS=0.2125p AD=0.19p
+ PS=1.425u PD=1.38u
M$1279 VPWR \$63 \$I4458 VPWR sg13_lv_pmos L=0.13u W=1u AS=0.19p AD=0.34p
+ PS=1.38u PD=2.68u
M$1280 \$268 \$I4457 VPWR VPWR sg13_lv_pmos L=0.13u W=1.12u AS=0.3808p
+ AD=0.3808p PS=2.92u PD=2.92u
M$1281 \$369 \$I4460 VGND VGND sg13_lv_nmos L=0.13u W=0.74u AS=0.2351p
+ AD=0.15745p PS=2.16u PD=1.175u
M$1282 VGND \$16 \$I4460 VGND sg13_lv_nmos L=0.13u W=0.64u AS=0.15745p
+ AD=0.1216p PS=1.175u PD=1.02u
M$1283 \$I4460 \$288 \$I4462 VGND sg13_lv_nmos L=0.13u W=0.64u AS=0.1216p
+ AD=0.0816p PS=1.02u PD=0.895u
M$1284 \$I4462 \$331 VGND VGND sg13_lv_nmos L=0.13u W=0.64u AS=0.0816p
+ AD=0.2176p PS=0.895u PD=1.96u
M$1285 \$I4460 \$16 \$I4461 VPWR sg13_lv_pmos L=0.13u W=1u AS=0.35p AD=0.2125p
+ PS=2.7u PD=1.425u
M$1286 \$I4461 \$288 VPWR VPWR sg13_lv_pmos L=0.13u W=1u AS=0.2125p AD=0.19p
+ PS=1.425u PD=1.38u
M$1287 VPWR \$331 \$I4461 VPWR sg13_lv_pmos L=0.13u W=1u AS=0.19p AD=0.34p
+ PS=1.38u PD=2.68u
M$1288 \$369 \$I4460 VPWR VPWR sg13_lv_pmos L=0.13u W=1.12u AS=0.3808p
+ AD=0.3808p PS=2.92u PD=2.92u
M$1289 \$413 \$I4463 VGND VGND sg13_lv_nmos L=0.13u W=0.74u AS=0.2351p
+ AD=0.15745p PS=2.16u PD=1.175u
M$1290 VGND \$44 \$I4463 VGND sg13_lv_nmos L=0.13u W=0.64u AS=0.15745p
+ AD=0.1216p PS=1.175u PD=1.02u
M$1291 \$I4463 \$396 \$I4465 VGND sg13_lv_nmos L=0.13u W=0.64u AS=0.1216p
+ AD=0.0816p PS=1.02u PD=0.895u
M$1292 \$I4465 \$300 VGND VGND sg13_lv_nmos L=0.13u W=0.64u AS=0.0816p
+ AD=0.2176p PS=0.895u PD=1.96u
M$1293 \$I4463 \$44 \$I4464 VPWR sg13_lv_pmos L=0.13u W=1u AS=0.35p AD=0.2125p
+ PS=2.7u PD=1.425u
M$1294 \$I4464 \$396 VPWR VPWR sg13_lv_pmos L=0.13u W=1u AS=0.2125p AD=0.19p
+ PS=1.425u PD=1.38u
M$1295 VPWR \$300 \$I4464 VPWR sg13_lv_pmos L=0.13u W=1u AS=0.19p AD=0.34p
+ PS=1.38u PD=2.68u
M$1296 \$413 \$I4463 VPWR VPWR sg13_lv_pmos L=0.13u W=1.12u AS=0.3808p
+ AD=0.3808p PS=2.92u PD=2.92u
M$1297 \$415 \$I4466 VGND VGND sg13_lv_nmos L=0.13u W=0.74u AS=0.2351p
+ AD=0.15745p PS=2.16u PD=1.175u
M$1298 VGND \$44 \$I4466 VGND sg13_lv_nmos L=0.13u W=0.64u AS=0.15745p
+ AD=0.1216p PS=1.175u PD=1.02u
M$1299 \$I4466 \$422 \$I4468 VGND sg13_lv_nmos L=0.13u W=0.64u AS=0.1216p
+ AD=0.0816p PS=1.02u PD=0.895u
M$1300 \$I4468 \$487 VGND VGND sg13_lv_nmos L=0.13u W=0.64u AS=0.0816p
+ AD=0.2176p PS=0.895u PD=1.96u
M$1301 \$I4466 \$44 \$I4467 VPWR sg13_lv_pmos L=0.13u W=1u AS=0.35p AD=0.2125p
+ PS=2.7u PD=1.425u
M$1302 \$I4467 \$422 VPWR VPWR sg13_lv_pmos L=0.13u W=1u AS=0.2125p AD=0.19p
+ PS=1.425u PD=1.38u
M$1303 VPWR \$487 \$I4467 VPWR sg13_lv_pmos L=0.13u W=1u AS=0.19p AD=0.34p
+ PS=1.38u PD=2.68u
M$1304 \$415 \$I4466 VPWR VPWR sg13_lv_pmos L=0.13u W=1.12u AS=0.3808p
+ AD=0.3808p PS=2.92u PD=2.92u
M$1305 \$472 \$I4469 VGND VGND sg13_lv_nmos L=0.13u W=0.74u AS=0.2351p
+ AD=0.15745p PS=2.16u PD=1.175u
M$1306 VGND \$470 \$I4469 VGND sg13_lv_nmos L=0.13u W=0.64u AS=0.15745p
+ AD=0.1216p PS=1.175u PD=1.02u
M$1307 \$I4469 \$504 \$I4471 VGND sg13_lv_nmos L=0.13u W=0.64u AS=0.1216p
+ AD=0.0816p PS=1.02u PD=0.895u
M$1308 \$I4471 \$316 VGND VGND sg13_lv_nmos L=0.13u W=0.64u AS=0.0816p
+ AD=0.2176p PS=0.895u PD=1.96u
M$1309 \$I4469 \$470 \$I4470 VPWR sg13_lv_pmos L=0.13u W=1u AS=0.35p AD=0.2125p
+ PS=2.7u PD=1.425u
M$1310 \$I4470 \$504 VPWR VPWR sg13_lv_pmos L=0.13u W=1u AS=0.2125p AD=0.19p
+ PS=1.425u PD=1.38u
M$1311 VPWR \$316 \$I4470 VPWR sg13_lv_pmos L=0.13u W=1u AS=0.19p AD=0.34p
+ PS=1.38u PD=2.68u
M$1312 \$472 \$I4469 VPWR VPWR sg13_lv_pmos L=0.13u W=1.12u AS=0.3808p
+ AD=0.3808p PS=2.92u PD=2.92u
M$1313 \$566 \$I4472 VGND VGND sg13_lv_nmos L=0.13u W=0.74u AS=0.2351p
+ AD=0.15745p PS=2.16u PD=1.175u
M$1314 VGND \$470 \$I4472 VGND sg13_lv_nmos L=0.13u W=0.64u AS=0.15745p
+ AD=0.1216p PS=1.175u PD=1.02u
M$1315 \$I4472 \$567 \$I4474 VGND sg13_lv_nmos L=0.13u W=0.64u AS=0.1216p
+ AD=0.0816p PS=1.02u PD=0.895u
M$1316 \$I4474 \$534 VGND VGND sg13_lv_nmos L=0.13u W=0.64u AS=0.0816p
+ AD=0.2176p PS=0.895u PD=1.96u
M$1317 \$I4472 \$470 \$I4473 VPWR sg13_lv_pmos L=0.13u W=1u AS=0.35p AD=0.2125p
+ PS=2.7u PD=1.425u
M$1318 \$I4473 \$567 VPWR VPWR sg13_lv_pmos L=0.13u W=1u AS=0.2125p AD=0.19p
+ PS=1.425u PD=1.38u
M$1319 VPWR \$534 \$I4473 VPWR sg13_lv_pmos L=0.13u W=1u AS=0.19p AD=0.34p
+ PS=1.38u PD=2.68u
M$1320 \$566 \$I4472 VPWR VPWR sg13_lv_pmos L=0.13u W=1.12u AS=0.3808p
+ AD=0.3808p PS=2.92u PD=2.92u
M$1321 \$552 \$I4475 VGND VGND sg13_lv_nmos L=0.13u W=0.74u AS=0.2351p
+ AD=0.15745p PS=2.16u PD=1.175u
M$1322 VGND \$470 \$I4475 VGND sg13_lv_nmos L=0.13u W=0.64u AS=0.15745p
+ AD=0.1216p PS=1.175u PD=1.02u
M$1323 \$I4475 \$629 \$I4477 VGND sg13_lv_nmos L=0.13u W=0.64u AS=0.1216p
+ AD=0.0816p PS=1.02u PD=0.895u
M$1324 \$I4477 \$536 VGND VGND sg13_lv_nmos L=0.13u W=0.64u AS=0.0816p
+ AD=0.2176p PS=0.895u PD=1.96u
M$1325 \$I4475 \$470 \$I4476 VPWR sg13_lv_pmos L=0.13u W=1u AS=0.35p AD=0.2125p
+ PS=2.7u PD=1.425u
M$1326 \$I4476 \$629 VPWR VPWR sg13_lv_pmos L=0.13u W=1u AS=0.2125p AD=0.19p
+ PS=1.425u PD=1.38u
M$1327 VPWR \$536 \$I4476 VPWR sg13_lv_pmos L=0.13u W=1u AS=0.19p AD=0.34p
+ PS=1.38u PD=2.68u
M$1328 \$552 \$I4475 VPWR VPWR sg13_lv_pmos L=0.13u W=1.12u AS=0.3808p
+ AD=0.3808p PS=2.92u PD=2.92u
M$1329 \$490 \$I4478 VGND VGND sg13_lv_nmos L=0.13u W=0.74u AS=0.2351p
+ AD=0.15745p PS=2.16u PD=1.175u
M$1330 VGND \$544 \$I4478 VGND sg13_lv_nmos L=0.13u W=0.64u AS=0.15745p
+ AD=0.1216p PS=1.175u PD=1.02u
M$1331 \$I4478 \$488 \$I4480 VGND sg13_lv_nmos L=0.13u W=0.64u AS=0.1216p
+ AD=0.0816p PS=1.02u PD=0.895u
M$1332 \$I4480 \$569 VGND VGND sg13_lv_nmos L=0.13u W=0.64u AS=0.0816p
+ AD=0.2176p PS=0.895u PD=1.96u
M$1333 \$I4478 \$544 \$I4479 VPWR sg13_lv_pmos L=0.13u W=1u AS=0.35p AD=0.2125p
+ PS=2.7u PD=1.425u
M$1334 \$I4479 \$488 VPWR VPWR sg13_lv_pmos L=0.13u W=1u AS=0.2125p AD=0.19p
+ PS=1.425u PD=1.38u
M$1335 VPWR \$569 \$I4479 VPWR sg13_lv_pmos L=0.13u W=1u AS=0.19p AD=0.34p
+ PS=1.38u PD=2.68u
M$1336 \$490 \$I4478 VPWR VPWR sg13_lv_pmos L=0.13u W=1.12u AS=0.3808p
+ AD=0.3808p PS=2.92u PD=2.92u
M$1337 \$597 \$I4481 VGND VGND sg13_lv_nmos L=0.13u W=0.74u AS=0.2351p
+ AD=0.15745p PS=2.16u PD=1.175u
M$1338 VGND \$44 \$I4481 VGND sg13_lv_nmos L=0.13u W=0.64u AS=0.15745p
+ AD=0.1216p PS=1.175u PD=1.02u
M$1339 \$I4481 \$68 \$I4483 VGND sg13_lv_nmos L=0.13u W=0.64u AS=0.1216p
+ AD=0.0816p PS=1.02u PD=0.895u
M$1340 \$I4483 \$543 VGND VGND sg13_lv_nmos L=0.13u W=0.64u AS=0.0816p
+ AD=0.2176p PS=0.895u PD=1.96u
M$1341 \$I4481 \$44 \$I4482 VPWR sg13_lv_pmos L=0.13u W=1u AS=0.35p AD=0.2125p
+ PS=2.7u PD=1.425u
M$1342 \$I4482 \$68 VPWR VPWR sg13_lv_pmos L=0.13u W=1u AS=0.2125p AD=0.19p
+ PS=1.425u PD=1.38u
M$1343 VPWR \$543 \$I4482 VPWR sg13_lv_pmos L=0.13u W=1u AS=0.19p AD=0.34p
+ PS=1.38u PD=2.68u
M$1344 \$597 \$I4481 VPWR VPWR sg13_lv_pmos L=0.13u W=1.12u AS=0.3808p
+ AD=0.3808p PS=2.92u PD=2.92u
M$1345 \$643 \$I4484 VGND VGND sg13_lv_nmos L=0.13u W=0.74u AS=0.2351p
+ AD=0.15745p PS=2.16u PD=1.175u
M$1346 VGND \$470 \$I4484 VGND sg13_lv_nmos L=0.13u W=0.64u AS=0.15745p
+ AD=0.1216p PS=1.175u PD=1.02u
M$1347 \$I4484 \$681 \$I4486 VGND sg13_lv_nmos L=0.13u W=0.64u AS=0.1216p
+ AD=0.0816p PS=1.02u PD=0.895u
M$1348 \$I4486 \$645 VGND VGND sg13_lv_nmos L=0.13u W=0.64u AS=0.0816p
+ AD=0.2176p PS=0.895u PD=1.96u
M$1349 \$I4484 \$470 \$I4485 VPWR sg13_lv_pmos L=0.13u W=1u AS=0.35p AD=0.2125p
+ PS=2.7u PD=1.425u
M$1350 \$I4485 \$681 VPWR VPWR sg13_lv_pmos L=0.13u W=1u AS=0.2125p AD=0.19p
+ PS=1.425u PD=1.38u
M$1351 VPWR \$645 \$I4485 VPWR sg13_lv_pmos L=0.13u W=1u AS=0.19p AD=0.34p
+ PS=1.38u PD=2.68u
M$1352 \$643 \$I4484 VPWR VPWR sg13_lv_pmos L=0.13u W=1.12u AS=0.3808p
+ AD=0.3808p PS=2.92u PD=2.92u
M$1353 \$725 \$I4487 VGND VGND sg13_lv_nmos L=0.13u W=0.74u AS=0.2351p
+ AD=0.15745p PS=2.16u PD=1.175u
M$1354 VGND \$44 \$I4487 VGND sg13_lv_nmos L=0.13u W=0.64u AS=0.15745p
+ AD=0.1216p PS=1.175u PD=1.02u
M$1355 \$I4487 \$661 \$I4489 VGND sg13_lv_nmos L=0.13u W=0.64u AS=0.1216p
+ AD=0.0816p PS=1.02u PD=0.895u
M$1356 \$I4489 \$434 VGND VGND sg13_lv_nmos L=0.13u W=0.64u AS=0.0816p
+ AD=0.2176p PS=0.895u PD=1.96u
M$1357 \$I4487 \$44 \$I4488 VPWR sg13_lv_pmos L=0.13u W=1u AS=0.35p AD=0.2125p
+ PS=2.7u PD=1.425u
M$1358 \$I4488 \$661 VPWR VPWR sg13_lv_pmos L=0.13u W=1u AS=0.2125p AD=0.19p
+ PS=1.425u PD=1.38u
M$1359 VPWR \$434 \$I4488 VPWR sg13_lv_pmos L=0.13u W=1u AS=0.19p AD=0.34p
+ PS=1.38u PD=2.68u
M$1360 \$725 \$I4487 VPWR VPWR sg13_lv_pmos L=0.13u W=1.12u AS=0.3808p
+ AD=0.3808p PS=2.92u PD=2.92u
M$1361 \$743 \$I4490 VGND VGND sg13_lv_nmos L=0.13u W=0.74u AS=0.2351p
+ AD=0.15745p PS=2.16u PD=1.175u
M$1362 VGND \$470 \$I4490 VGND sg13_lv_nmos L=0.13u W=0.64u AS=0.15745p
+ AD=0.1216p PS=1.175u PD=1.02u
M$1363 \$I4490 \$691 \$I4492 VGND sg13_lv_nmos L=0.13u W=0.64u AS=0.1216p
+ AD=0.0816p PS=1.02u PD=0.895u
M$1364 \$I4492 \$627 VGND VGND sg13_lv_nmos L=0.13u W=0.64u AS=0.0816p
+ AD=0.2176p PS=0.895u PD=1.96u
M$1365 \$I4490 \$470 \$I4491 VPWR sg13_lv_pmos L=0.13u W=1u AS=0.35p AD=0.2125p
+ PS=2.7u PD=1.425u
M$1366 \$I4491 \$691 VPWR VPWR sg13_lv_pmos L=0.13u W=1u AS=0.2125p AD=0.19p
+ PS=1.425u PD=1.38u
M$1367 VPWR \$627 \$I4491 VPWR sg13_lv_pmos L=0.13u W=1u AS=0.19p AD=0.34p
+ PS=1.38u PD=2.68u
M$1368 \$743 \$I4490 VPWR VPWR sg13_lv_pmos L=0.13u W=1.12u AS=0.3808p
+ AD=0.3808p PS=2.92u PD=2.92u
M$1369 \$746 \$I4493 VGND VGND sg13_lv_nmos L=0.13u W=0.74u AS=0.2351p
+ AD=0.15745p PS=2.16u PD=1.175u
M$1370 VGND \$470 \$I4493 VGND sg13_lv_nmos L=0.13u W=0.64u AS=0.15745p
+ AD=0.1216p PS=1.175u PD=1.02u
M$1371 \$I4493 \$774 \$I4495 VGND sg13_lv_nmos L=0.13u W=0.64u AS=0.1216p
+ AD=0.0816p PS=1.02u PD=0.895u
M$1372 \$I4495 \$714 VGND VGND sg13_lv_nmos L=0.13u W=0.64u AS=0.0816p
+ AD=0.2176p PS=0.895u PD=1.96u
M$1373 \$I4493 \$470 \$I4494 VPWR sg13_lv_pmos L=0.13u W=1u AS=0.35p AD=0.2125p
+ PS=2.7u PD=1.425u
M$1374 \$I4494 \$774 VPWR VPWR sg13_lv_pmos L=0.13u W=1u AS=0.2125p AD=0.19p
+ PS=1.425u PD=1.38u
M$1375 VPWR \$714 \$I4494 VPWR sg13_lv_pmos L=0.13u W=1u AS=0.19p AD=0.34p
+ PS=1.38u PD=2.68u
M$1376 \$746 \$I4493 VPWR VPWR sg13_lv_pmos L=0.13u W=1.12u AS=0.3808p
+ AD=0.3808p PS=2.92u PD=2.92u
M$1377 \$776 \$I4496 VGND VGND sg13_lv_nmos L=0.13u W=0.74u AS=0.2351p
+ AD=0.15745p PS=2.16u PD=1.175u
M$1378 VGND \$470 \$I4496 VGND sg13_lv_nmos L=0.13u W=0.64u AS=0.15745p
+ AD=0.1216p PS=1.175u PD=1.02u
M$1379 \$I4496 \$747 \$I4498 VGND sg13_lv_nmos L=0.13u W=0.64u AS=0.1216p
+ AD=0.0816p PS=1.02u PD=0.895u
M$1380 \$I4498 \$715 VGND VGND sg13_lv_nmos L=0.13u W=0.64u AS=0.0816p
+ AD=0.2176p PS=0.895u PD=1.96u
M$1381 \$I4496 \$470 \$I4497 VPWR sg13_lv_pmos L=0.13u W=1u AS=0.35p AD=0.2125p
+ PS=2.7u PD=1.425u
M$1382 \$I4497 \$747 VPWR VPWR sg13_lv_pmos L=0.13u W=1u AS=0.2125p AD=0.19p
+ PS=1.425u PD=1.38u
M$1383 VPWR \$715 \$I4497 VPWR sg13_lv_pmos L=0.13u W=1u AS=0.19p AD=0.34p
+ PS=1.38u PD=2.68u
M$1384 \$776 \$I4496 VPWR VPWR sg13_lv_pmos L=0.13u W=1.12u AS=0.3808p
+ AD=0.3808p PS=2.92u PD=2.92u
M$1385 \$749 \$I4499 VGND VGND sg13_lv_nmos L=0.13u W=0.74u AS=0.2351p
+ AD=0.15745p PS=2.16u PD=1.175u
M$1386 VGND \$44 \$I4499 VGND sg13_lv_nmos L=0.13u W=0.64u AS=0.15745p
+ AD=0.1216p PS=1.175u PD=1.02u
M$1387 \$I4499 \$750 \$I4501 VGND sg13_lv_nmos L=0.13u W=0.64u AS=0.1216p
+ AD=0.0816p PS=1.02u PD=0.895u
M$1388 \$I4501 \$706 VGND VGND sg13_lv_nmos L=0.13u W=0.64u AS=0.0816p
+ AD=0.2176p PS=0.895u PD=1.96u
M$1389 \$I4499 \$44 \$I4500 VPWR sg13_lv_pmos L=0.13u W=1u AS=0.35p AD=0.2125p
+ PS=2.7u PD=1.425u
M$1390 \$I4500 \$750 VPWR VPWR sg13_lv_pmos L=0.13u W=1u AS=0.2125p AD=0.19p
+ PS=1.425u PD=1.38u
M$1391 VPWR \$706 \$I4500 VPWR sg13_lv_pmos L=0.13u W=1u AS=0.19p AD=0.34p
+ PS=1.38u PD=2.68u
M$1392 \$749 \$I4499 VPWR VPWR sg13_lv_pmos L=0.13u W=1.12u AS=0.3808p
+ AD=0.3808p PS=2.92u PD=2.92u
M$1393 \$751 \$I4502 VGND VGND sg13_lv_nmos L=0.13u W=0.74u AS=0.2351p
+ AD=0.15745p PS=2.16u PD=1.175u
M$1394 VGND \$544 \$I4502 VGND sg13_lv_nmos L=0.13u W=0.64u AS=0.15745p
+ AD=0.1216p PS=1.175u PD=1.02u
M$1395 \$I4502 \$782 \$I4504 VGND sg13_lv_nmos L=0.13u W=0.64u AS=0.1216p
+ AD=0.0816p PS=1.02u PD=0.895u
M$1396 \$I4504 \$668 VGND VGND sg13_lv_nmos L=0.13u W=0.64u AS=0.0816p
+ AD=0.2176p PS=0.895u PD=1.96u
M$1397 \$I4502 \$544 \$I4503 VPWR sg13_lv_pmos L=0.13u W=1u AS=0.35p AD=0.2125p
+ PS=2.7u PD=1.425u
M$1398 \$I4503 \$782 VPWR VPWR sg13_lv_pmos L=0.13u W=1u AS=0.2125p AD=0.19p
+ PS=1.425u PD=1.38u
M$1399 VPWR \$668 \$I4503 VPWR sg13_lv_pmos L=0.13u W=1u AS=0.19p AD=0.34p
+ PS=1.38u PD=2.68u
M$1400 \$751 \$I4502 VPWR VPWR sg13_lv_pmos L=0.13u W=1.12u AS=0.3808p
+ AD=0.3808p PS=2.92u PD=2.92u
M$1401 \$754 \$I4505 VGND VGND sg13_lv_nmos L=0.13u W=0.74u AS=0.2351p
+ AD=0.15745p PS=2.16u PD=1.175u
M$1402 VGND \$544 \$I4505 VGND sg13_lv_nmos L=0.13u W=0.64u AS=0.15745p
+ AD=0.1216p PS=1.175u PD=1.02u
M$1403 \$I4505 \$771 \$I4507 VGND sg13_lv_nmos L=0.13u W=0.64u AS=0.1216p
+ AD=0.0816p PS=1.02u PD=0.895u
M$1404 \$I4507 \$720 VGND VGND sg13_lv_nmos L=0.13u W=0.64u AS=0.0816p
+ AD=0.2176p PS=0.895u PD=1.96u
M$1405 \$I4505 \$544 \$I4506 VPWR sg13_lv_pmos L=0.13u W=1u AS=0.35p AD=0.2125p
+ PS=2.7u PD=1.425u
M$1406 \$I4506 \$771 VPWR VPWR sg13_lv_pmos L=0.13u W=1u AS=0.2125p AD=0.19p
+ PS=1.425u PD=1.38u
M$1407 VPWR \$720 \$I4506 VPWR sg13_lv_pmos L=0.13u W=1u AS=0.19p AD=0.34p
+ PS=1.38u PD=2.68u
M$1408 \$754 \$I4505 VPWR VPWR sg13_lv_pmos L=0.13u W=1.12u AS=0.3808p
+ AD=0.3808p PS=2.92u PD=2.92u
M$1409 \$885 \$I4508 VGND VGND sg13_lv_nmos L=0.13u W=0.74u AS=0.2351p
+ AD=0.15745p PS=2.16u PD=1.175u
M$1410 VGND \$544 \$I4508 VGND sg13_lv_nmos L=0.13u W=0.64u AS=0.15745p
+ AD=0.1216p PS=1.175u PD=1.02u
M$1411 \$I4508 \$888 \$I4510 VGND sg13_lv_nmos L=0.13u W=0.64u AS=0.1216p
+ AD=0.0816p PS=1.02u PD=0.895u
M$1412 \$I4510 \$716 VGND VGND sg13_lv_nmos L=0.13u W=0.64u AS=0.0816p
+ AD=0.2176p PS=0.895u PD=1.96u
M$1413 \$I4508 \$544 \$I4509 VPWR sg13_lv_pmos L=0.13u W=1u AS=0.35p AD=0.2125p
+ PS=2.7u PD=1.425u
M$1414 \$I4509 \$888 VPWR VPWR sg13_lv_pmos L=0.13u W=1u AS=0.2125p AD=0.19p
+ PS=1.425u PD=1.38u
M$1415 VPWR \$716 \$I4509 VPWR sg13_lv_pmos L=0.13u W=1u AS=0.19p AD=0.34p
+ PS=1.38u PD=2.68u
M$1416 \$885 \$I4508 VPWR VPWR sg13_lv_pmos L=0.13u W=1.12u AS=0.3808p
+ AD=0.3808p PS=2.92u PD=2.92u
M$1417 \$896 \$I4511 VGND VGND sg13_lv_nmos L=0.13u W=0.74u AS=0.2351p
+ AD=0.15745p PS=2.16u PD=1.175u
M$1418 VGND \$544 \$I4511 VGND sg13_lv_nmos L=0.13u W=0.64u AS=0.15745p
+ AD=0.1216p PS=1.175u PD=1.02u
M$1419 \$I4511 \$909 \$I4513 VGND sg13_lv_nmos L=0.13u W=0.64u AS=0.1216p
+ AD=0.0816p PS=1.02u PD=0.895u
M$1420 \$I4513 \$809 VGND VGND sg13_lv_nmos L=0.13u W=0.64u AS=0.0816p
+ AD=0.2176p PS=0.895u PD=1.96u
M$1421 \$I4511 \$544 \$I4512 VPWR sg13_lv_pmos L=0.13u W=1u AS=0.35p AD=0.2125p
+ PS=2.7u PD=1.425u
M$1422 \$I4512 \$909 VPWR VPWR sg13_lv_pmos L=0.13u W=1u AS=0.2125p AD=0.19p
+ PS=1.425u PD=1.38u
M$1423 VPWR \$809 \$I4512 VPWR sg13_lv_pmos L=0.13u W=1u AS=0.19p AD=0.34p
+ PS=1.38u PD=2.68u
M$1424 \$896 \$I4511 VPWR VPWR sg13_lv_pmos L=0.13u W=1.12u AS=0.3808p
+ AD=0.3808p PS=2.92u PD=2.92u
M$1425 VGND \$58 \$I4515 VGND sg13_lv_nmos L=0.13u W=0.74u AS=0.2886p
+ AD=0.1406p PS=2.26u PD=1.12u
M$1426 \$I4515 \$59 \$I4514 VGND sg13_lv_nmos L=0.13u W=0.74u AS=0.1406p
+ AD=0.1406p PS=1.12u PD=1.12u
M$1427 \$I4514 \$136 \$77 VGND sg13_lv_nmos L=0.13u W=0.74u AS=0.1406p
+ AD=0.2516p PS=1.12u PD=2.16u
M$1428 VPWR \$58 \$77 VPWR sg13_lv_pmos L=0.13u W=1.12u AS=0.3808p AD=0.2128p
+ PS=2.92u PD=1.5u
M$1429 \$77 \$59 VPWR VPWR sg13_lv_pmos L=0.13u W=1.12u AS=0.2128p AD=0.2128p
+ PS=1.5u PD=1.5u
M$1430 VPWR \$136 \$77 VPWR sg13_lv_pmos L=0.13u W=1.12u AS=0.2128p AD=0.3808p
+ PS=1.5u PD=2.92u
M$1431 VGND \$59 \$I4517 VGND sg13_lv_nmos L=0.13u W=0.74u AS=0.2886p
+ AD=0.1406p PS=2.26u PD=1.12u
M$1432 \$I4517 \$136 \$I4516 VGND sg13_lv_nmos L=0.13u W=0.74u AS=0.1406p
+ AD=0.1406p PS=1.12u PD=1.12u
M$1433 \$I4516 \$174 \$39 VGND sg13_lv_nmos L=0.13u W=0.74u AS=0.1406p
+ AD=0.2516p PS=1.12u PD=2.16u
M$1434 VPWR \$59 \$39 VPWR sg13_lv_pmos L=0.13u W=1.12u AS=0.3808p AD=0.2128p
+ PS=2.92u PD=1.5u
M$1435 \$39 \$136 VPWR VPWR sg13_lv_pmos L=0.13u W=1.12u AS=0.2128p AD=0.2128p
+ PS=1.5u PD=1.5u
M$1436 VPWR \$174 \$39 VPWR sg13_lv_pmos L=0.13u W=1.12u AS=0.2128p AD=0.3808p
+ PS=1.5u PD=2.92u
M$1437 VGND \$58 \$I4519 VGND sg13_lv_nmos L=0.13u W=0.74u AS=0.2886p
+ AD=0.1406p PS=2.26u PD=1.12u
M$1438 \$I4519 \$63 \$I4518 VGND sg13_lv_nmos L=0.13u W=0.74u AS=0.1406p
+ AD=0.1406p PS=1.12u PD=1.12u
M$1439 \$I4518 \$136 \$33 VGND sg13_lv_nmos L=0.13u W=0.74u AS=0.1406p
+ AD=0.2516p PS=1.12u PD=2.16u
M$1440 VPWR \$58 \$33 VPWR sg13_lv_pmos L=0.13u W=1.12u AS=0.3808p AD=0.2128p
+ PS=2.92u PD=1.5u
M$1441 \$33 \$63 VPWR VPWR sg13_lv_pmos L=0.13u W=1.12u AS=0.2128p AD=0.2128p
+ PS=1.5u PD=1.5u
M$1442 VPWR \$136 \$33 VPWR sg13_lv_pmos L=0.13u W=1.12u AS=0.2128p AD=0.3808p
+ PS=1.5u PD=2.92u
M$1443 VGND \$298 \$I4521 VGND sg13_lv_nmos L=0.13u W=0.74u AS=0.2886p
+ AD=0.1406p PS=2.26u PD=1.12u
M$1444 \$I4521 \$136 \$I4520 VGND sg13_lv_nmos L=0.13u W=0.74u AS=0.1406p
+ AD=0.1406p PS=1.12u PD=1.12u
M$1445 \$I4520 \$174 \$316 VGND sg13_lv_nmos L=0.13u W=0.74u AS=0.1406p
+ AD=0.2516p PS=1.12u PD=2.16u
M$1446 VPWR \$298 \$316 VPWR sg13_lv_pmos L=0.13u W=1.12u AS=0.3808p AD=0.2128p
+ PS=2.92u PD=1.5u
M$1447 \$316 \$136 VPWR VPWR sg13_lv_pmos L=0.13u W=1.12u AS=0.2128p AD=0.2128p
+ PS=1.5u PD=1.5u
M$1448 VPWR \$174 \$316 VPWR sg13_lv_pmos L=0.13u W=1.12u AS=0.2128p AD=0.3808p
+ PS=1.5u PD=2.92u
M$1449 VGND \$58 \$I4523 VGND sg13_lv_nmos L=0.13u W=0.74u AS=0.2886p
+ AD=0.1406p PS=2.26u PD=1.12u
M$1450 \$I4523 \$298 \$I4522 VGND sg13_lv_nmos L=0.13u W=0.74u AS=0.1406p
+ AD=0.1406p PS=1.12u PD=1.12u
M$1451 \$I4522 \$136 \$331 VGND sg13_lv_nmos L=0.13u W=0.74u AS=0.1406p
+ AD=0.2516p PS=1.12u PD=2.16u
M$1452 VPWR \$58 \$331 VPWR sg13_lv_pmos L=0.13u W=1.12u AS=0.3808p AD=0.2128p
+ PS=2.92u PD=1.5u
M$1453 \$331 \$298 VPWR VPWR sg13_lv_pmos L=0.13u W=1.12u AS=0.2128p AD=0.2128p
+ PS=1.5u PD=1.5u
M$1454 VPWR \$136 \$331 VPWR sg13_lv_pmos L=0.13u W=1.12u AS=0.2128p AD=0.3808p
+ PS=1.5u PD=2.92u
M$1455 VGND \$450 \$I4525 VGND sg13_lv_nmos L=0.13u W=0.74u AS=0.2886p
+ AD=0.1406p PS=2.26u PD=1.12u
M$1456 \$I4525 \$63 \$I4524 VGND sg13_lv_nmos L=0.13u W=0.74u AS=0.1406p
+ AD=0.1406p PS=1.12u PD=1.12u
M$1457 \$I4524 \$370 \$434 VGND sg13_lv_nmos L=0.13u W=0.74u AS=0.1406p
+ AD=0.2516p PS=1.12u PD=2.16u
M$1458 VPWR \$450 \$434 VPWR sg13_lv_pmos L=0.13u W=1.12u AS=0.3808p AD=0.2128p
+ PS=2.92u PD=1.5u
M$1459 \$434 \$63 VPWR VPWR sg13_lv_pmos L=0.13u W=1.12u AS=0.2128p AD=0.2128p
+ PS=1.5u PD=1.5u
M$1460 VPWR \$370 \$434 VPWR sg13_lv_pmos L=0.13u W=1.12u AS=0.2128p AD=0.3808p
+ PS=1.5u PD=2.92u
M$1461 VGND \$63 \$I4527 VGND sg13_lv_nmos L=0.13u W=0.74u AS=0.2886p
+ AD=0.1406p PS=2.26u PD=1.12u
M$1462 \$I4527 \$136 \$I4526 VGND sg13_lv_nmos L=0.13u W=0.74u AS=0.1406p
+ AD=0.1406p PS=1.12u PD=1.12u
M$1463 \$I4526 \$174 \$40 VGND sg13_lv_nmos L=0.13u W=0.74u AS=0.1406p
+ AD=0.2516p PS=1.12u PD=2.16u
M$1464 VPWR \$63 \$40 VPWR sg13_lv_pmos L=0.13u W=1.12u AS=0.3808p AD=0.2128p
+ PS=2.92u PD=1.5u
M$1465 \$40 \$136 VPWR VPWR sg13_lv_pmos L=0.13u W=1.12u AS=0.2128p AD=0.2128p
+ PS=1.5u PD=1.5u
M$1466 VPWR \$174 \$40 VPWR sg13_lv_pmos L=0.13u W=1.12u AS=0.2128p AD=0.3808p
+ PS=1.5u PD=2.92u
M$1467 VGND \$58 \$I4529 VGND sg13_lv_nmos L=0.13u W=0.74u AS=0.2886p
+ AD=0.1406p PS=2.26u PD=1.12u
M$1468 \$I4529 \$538 \$I4528 VGND sg13_lv_nmos L=0.13u W=0.74u AS=0.1406p
+ AD=0.1406p PS=1.12u PD=1.12u
M$1469 \$I4528 \$63 \$536 VGND sg13_lv_nmos L=0.13u W=0.74u AS=0.1406p
+ AD=0.2516p PS=1.12u PD=2.16u
M$1470 VPWR \$58 \$536 VPWR sg13_lv_pmos L=0.13u W=1.12u AS=0.3808p AD=0.2128p
+ PS=2.92u PD=1.5u
M$1471 \$536 \$538 VPWR VPWR sg13_lv_pmos L=0.13u W=1.12u AS=0.2128p AD=0.2128p
+ PS=1.5u PD=1.5u
M$1472 VPWR \$63 \$536 VPWR sg13_lv_pmos L=0.13u W=1.12u AS=0.2128p AD=0.3808p
+ PS=1.5u PD=2.92u
M$1473 VGND \$298 \$I4531 VGND sg13_lv_nmos L=0.13u W=0.74u AS=0.2886p
+ AD=0.1406p PS=2.26u PD=1.12u
M$1474 \$I4531 \$450 \$I4530 VGND sg13_lv_nmos L=0.13u W=0.74u AS=0.1406p
+ AD=0.1406p PS=1.12u PD=1.12u
M$1475 \$I4530 \$370 \$809 VGND sg13_lv_nmos L=0.13u W=0.74u AS=0.1406p
+ AD=0.2516p PS=1.12u PD=2.16u
M$1476 VPWR \$298 \$809 VPWR sg13_lv_pmos L=0.13u W=1.12u AS=0.3808p AD=0.2128p
+ PS=2.92u PD=1.5u
M$1477 \$809 \$450 VPWR VPWR sg13_lv_pmos L=0.13u W=1.12u AS=0.2128p AD=0.2128p
+ PS=1.5u PD=1.5u
M$1478 VPWR \$370 \$809 VPWR sg13_lv_pmos L=0.13u W=1.12u AS=0.2128p AD=0.3808p
+ PS=1.5u PD=2.92u
M$1479 VGND \$538 \$I4533 VGND sg13_lv_nmos L=0.13u W=0.74u AS=0.2886p
+ AD=0.1406p PS=2.26u PD=1.12u
M$1480 \$I4533 \$59 \$I4532 VGND sg13_lv_nmos L=0.13u W=0.74u AS=0.1406p
+ AD=0.1406p PS=1.12u PD=1.12u
M$1481 \$I4532 \$174 \$627 VGND sg13_lv_nmos L=0.13u W=0.74u AS=0.1406p
+ AD=0.2516p PS=1.12u PD=2.16u
M$1482 VPWR \$538 \$627 VPWR sg13_lv_pmos L=0.13u W=1.12u AS=0.3808p AD=0.2128p
+ PS=2.92u PD=1.5u
M$1483 \$627 \$59 VPWR VPWR sg13_lv_pmos L=0.13u W=1.12u AS=0.2128p AD=0.2128p
+ PS=1.5u PD=1.5u
M$1484 VPWR \$174 \$627 VPWR sg13_lv_pmos L=0.13u W=1.12u AS=0.2128p AD=0.3808p
+ PS=1.5u PD=2.92u
M$1485 VGND \$538 \$I4535 VGND sg13_lv_nmos L=0.13u W=0.74u AS=0.2886p
+ AD=0.1406p PS=2.26u PD=1.12u
M$1486 \$I4535 \$63 \$I4534 VGND sg13_lv_nmos L=0.13u W=0.74u AS=0.1406p
+ AD=0.1406p PS=1.12u PD=1.12u
M$1487 \$I4534 \$174 \$534 VGND sg13_lv_nmos L=0.13u W=0.74u AS=0.1406p
+ AD=0.2516p PS=1.12u PD=2.16u
M$1488 VPWR \$538 \$534 VPWR sg13_lv_pmos L=0.13u W=1.12u AS=0.3808p AD=0.2128p
+ PS=2.92u PD=1.5u
M$1489 \$534 \$63 VPWR VPWR sg13_lv_pmos L=0.13u W=1.12u AS=0.2128p AD=0.2128p
+ PS=1.5u PD=1.5u
M$1490 VPWR \$174 \$534 VPWR sg13_lv_pmos L=0.13u W=1.12u AS=0.2128p AD=0.3808p
+ PS=1.5u PD=2.92u
M$1491 VGND \$58 \$I4537 VGND sg13_lv_nmos L=0.13u W=0.74u AS=0.2886p
+ AD=0.1406p PS=2.26u PD=1.12u
M$1492 \$I4537 \$538 \$I4536 VGND sg13_lv_nmos L=0.13u W=0.74u AS=0.1406p
+ AD=0.1406p PS=1.12u PD=1.12u
M$1493 \$I4536 \$59 \$715 VGND sg13_lv_nmos L=0.13u W=0.74u AS=0.1406p
+ AD=0.2516p PS=1.12u PD=2.16u
M$1494 VPWR \$58 \$715 VPWR sg13_lv_pmos L=0.13u W=1.12u AS=0.3808p AD=0.2128p
+ PS=2.92u PD=1.5u
M$1495 \$715 \$538 VPWR VPWR sg13_lv_pmos L=0.13u W=1.12u AS=0.2128p AD=0.2128p
+ PS=1.5u PD=1.5u
M$1496 VPWR \$59 \$715 VPWR sg13_lv_pmos L=0.13u W=1.12u AS=0.2128p AD=0.3808p
+ PS=1.5u PD=2.92u
M$1497 VGND \$58 \$I4539 VGND sg13_lv_nmos L=0.13u W=0.74u AS=0.2886p
+ AD=0.1406p PS=2.26u PD=1.12u
M$1498 \$I4539 \$298 \$I4538 VGND sg13_lv_nmos L=0.13u W=0.74u AS=0.1406p
+ AD=0.1406p PS=1.12u PD=1.12u
M$1499 \$I4538 \$538 \$645 VGND sg13_lv_nmos L=0.13u W=0.74u AS=0.1406p
+ AD=0.2516p PS=1.12u PD=2.16u
M$1500 VPWR \$58 \$645 VPWR sg13_lv_pmos L=0.13u W=1.12u AS=0.3808p AD=0.2128p
+ PS=2.92u PD=1.5u
M$1501 \$645 \$298 VPWR VPWR sg13_lv_pmos L=0.13u W=1.12u AS=0.2128p AD=0.2128p
+ PS=1.5u PD=1.5u
M$1502 VPWR \$538 \$645 VPWR sg13_lv_pmos L=0.13u W=1.12u AS=0.2128p AD=0.3808p
+ PS=1.5u PD=2.92u
M$1503 VGND \$59 \$I4541 VGND sg13_lv_nmos L=0.13u W=0.74u AS=0.2886p
+ AD=0.1406p PS=2.26u PD=1.12u
M$1504 \$I4541 \$450 \$I4540 VGND sg13_lv_nmos L=0.13u W=0.74u AS=0.1406p
+ AD=0.1406p PS=1.12u PD=1.12u
M$1505 \$I4540 \$174 \$706 VGND sg13_lv_nmos L=0.13u W=0.74u AS=0.1406p
+ AD=0.2516p PS=1.12u PD=2.16u
M$1506 VPWR \$59 \$706 VPWR sg13_lv_pmos L=0.13u W=1.12u AS=0.3808p AD=0.2128p
+ PS=2.92u PD=1.5u
M$1507 \$706 \$450 VPWR VPWR sg13_lv_pmos L=0.13u W=1.12u AS=0.2128p AD=0.2128p
+ PS=1.5u PD=1.5u
M$1508 VPWR \$174 \$706 VPWR sg13_lv_pmos L=0.13u W=1.12u AS=0.2128p AD=0.3808p
+ PS=1.5u PD=2.92u
M$1509 VGND \$491 \$I4543 VGND sg13_lv_nmos L=0.13u W=0.74u AS=0.2886p
+ AD=0.1406p PS=2.26u PD=1.12u
M$1510 \$I4543 \$298 \$I4542 VGND sg13_lv_nmos L=0.13u W=0.74u AS=0.1406p
+ AD=0.1406p PS=1.12u PD=1.12u
M$1511 \$I4542 \$450 \$668 VGND sg13_lv_nmos L=0.13u W=0.74u AS=0.1406p
+ AD=0.2516p PS=1.12u PD=2.16u
M$1512 VPWR \$491 \$668 VPWR sg13_lv_pmos L=0.13u W=1.12u AS=0.3808p AD=0.2128p
+ PS=2.92u PD=1.5u
M$1513 \$668 \$298 VPWR VPWR sg13_lv_pmos L=0.13u W=1.12u AS=0.2128p AD=0.2128p
+ PS=1.5u PD=1.5u
M$1514 VPWR \$450 \$668 VPWR sg13_lv_pmos L=0.13u W=1.12u AS=0.2128p AD=0.3808p
+ PS=1.5u PD=2.92u
M$1515 VGND \$298 \$I4545 VGND sg13_lv_nmos L=0.13u W=0.74u AS=0.2886p
+ AD=0.1406p PS=2.26u PD=1.12u
M$1516 \$I4545 \$538 \$I4544 VGND sg13_lv_nmos L=0.13u W=0.74u AS=0.1406p
+ AD=0.1406p PS=1.12u PD=1.12u
M$1517 \$I4544 \$174 \$714 VGND sg13_lv_nmos L=0.13u W=0.74u AS=0.1406p
+ AD=0.2516p PS=1.12u PD=2.16u
M$1518 VPWR \$298 \$714 VPWR sg13_lv_pmos L=0.13u W=1.12u AS=0.3808p AD=0.2128p
+ PS=2.92u PD=1.5u
M$1519 \$714 \$538 VPWR VPWR sg13_lv_pmos L=0.13u W=1.12u AS=0.2128p AD=0.2128p
+ PS=1.5u PD=1.5u
M$1520 VPWR \$174 \$714 VPWR sg13_lv_pmos L=0.13u W=1.12u AS=0.2128p AD=0.3808p
+ PS=1.5u PD=2.92u
M$1521 VGND \$58 \$I4547 VGND sg13_lv_nmos L=0.13u W=0.74u AS=0.2886p
+ AD=0.1406p PS=2.26u PD=1.12u
M$1522 \$I4547 \$59 \$I4546 VGND sg13_lv_nmos L=0.13u W=0.74u AS=0.1406p
+ AD=0.1406p PS=1.12u PD=1.12u
M$1523 \$I4546 \$450 \$716 VGND sg13_lv_nmos L=0.13u W=0.74u AS=0.1406p
+ AD=0.2516p PS=1.12u PD=2.16u
M$1524 VPWR \$58 \$716 VPWR sg13_lv_pmos L=0.13u W=1.12u AS=0.3808p AD=0.2128p
+ PS=2.92u PD=1.5u
M$1525 \$716 \$59 VPWR VPWR sg13_lv_pmos L=0.13u W=1.12u AS=0.2128p AD=0.2128p
+ PS=1.5u PD=1.5u
M$1526 VPWR \$450 \$716 VPWR sg13_lv_pmos L=0.13u W=1.12u AS=0.2128p AD=0.3808p
+ PS=1.5u PD=2.92u
M$1527 VGND \$491 \$I4549 VGND sg13_lv_nmos L=0.13u W=0.74u AS=0.2886p
+ AD=0.1406p PS=2.26u PD=1.12u
M$1528 \$I4549 \$450 \$I4548 VGND sg13_lv_nmos L=0.13u W=0.74u AS=0.1406p
+ AD=0.1406p PS=1.12u PD=1.12u
M$1529 \$I4548 \$431 \$720 VGND sg13_lv_nmos L=0.13u W=0.74u AS=0.1406p
+ AD=0.2516p PS=1.12u PD=2.16u
M$1530 VPWR \$491 \$720 VPWR sg13_lv_pmos L=0.13u W=1.12u AS=0.3808p AD=0.2128p
+ PS=2.92u PD=1.5u
M$1531 \$720 \$450 VPWR VPWR sg13_lv_pmos L=0.13u W=1.12u AS=0.2128p AD=0.2128p
+ PS=1.5u PD=1.5u
M$1532 VPWR \$431 \$720 VPWR sg13_lv_pmos L=0.13u W=1.12u AS=0.2128p AD=0.3808p
+ PS=1.5u PD=2.92u
M$1533 VGND \$20 \$I4550 VGND sg13_lv_nmos L=0.13u W=0.55u AS=0.17255p
+ AD=0.187p PS=1.25u PD=1.78u
M$1534 VGND \$I4550 \$526 VGND sg13_lv_nmos L=0.13u W=0.74u AS=0.17255p
+ AD=0.1406p PS=1.25u PD=1.12u
M$1535 \$526 \$28 VGND VGND sg13_lv_nmos L=0.13u W=0.74u AS=0.1406p AD=0.2516p
+ PS=1.12u PD=2.16u
M$1536 \$I4550 \$20 VPWR VPWR sg13_lv_pmos L=0.13u W=0.84u AS=0.2856p
+ AD=0.2618p PS=2.36u PD=1.63u
M$1537 VPWR \$I4550 \$I4551 VPWR sg13_lv_pmos L=0.13u W=1.12u AS=0.2618p
+ AD=0.1176p PS=1.63u PD=1.33u
M$1538 \$I4551 \$28 \$526 VPWR sg13_lv_pmos L=0.13u W=1.12u AS=0.1176p
+ AD=0.3808p PS=1.33u PD=2.92u
M$1539 VGND \$28 \$I4552 VGND sg13_lv_nmos L=0.13u W=0.55u AS=0.17255p
+ AD=0.187p PS=1.25u PD=1.78u
M$1540 VGND \$I4552 \$394 VGND sg13_lv_nmos L=0.13u W=0.74u AS=0.17255p
+ AD=0.1406p PS=1.25u PD=1.12u
M$1541 \$394 \$20 VGND VGND sg13_lv_nmos L=0.13u W=0.74u AS=0.1406p AD=0.2516p
+ PS=1.12u PD=2.16u
M$1542 \$I4552 \$28 VPWR VPWR sg13_lv_pmos L=0.13u W=0.84u AS=0.2856p
+ AD=0.2618p PS=2.36u PD=1.63u
M$1543 VPWR \$I4552 \$I4553 VPWR sg13_lv_pmos L=0.13u W=1.12u AS=0.2618p
+ AD=0.1176p PS=1.63u PD=1.33u
M$1544 \$I4553 \$20 \$394 VPWR sg13_lv_pmos L=0.13u W=1.12u AS=0.1176p
+ AD=0.3808p PS=1.33u PD=2.92u
M$1545 VGND VPWR VGND VGND sg13_lv_nmos L=1u W=38.64u AS=10.6176p AD=10.6176p
+ PS=111.04u PD=111.04u
M$1546 VPWR VGND VPWR VPWR sg13_lv_pmos L=1u W=92u AS=25.28p AD=25.28p
+ PS=194.56u PD=194.56u
M$1729 VGND \$I4636 \$18 VGND sg13_lv_nmos L=0.13u W=1.48u AS=0.39405p
+ AD=0.39405p PS=3.285u PD=3.285u
M$1731 \$I4638 \$I4632 \$I4635 VGND sg13_lv_nmos L=0.13u W=0.42u AS=0.12665p
+ AD=0.1428p PS=1.145u PD=1.52u
M$1732 \$I4631 \$I4643 \$I4638 VGND sg13_lv_nmos L=0.13u W=0.74u AS=0.3473p
+ AD=0.12665p PS=2.71u PD=1.145u
M$1733 VGND \$I4632 \$I4643 VGND sg13_lv_nmos L=0.13u W=0.74u AS=0.43315p
+ AD=0.2516p PS=2.205u PD=2.16u
M$1734 VGND \$52 \$I4632 VGND sg13_lv_nmos L=0.13u W=0.74u AS=0.43315p
+ AD=0.2516p PS=2.205u PD=2.16u
M$1735 \$I4633 \$I4632 \$I4637 VGND sg13_lv_nmos L=0.13u W=0.42u AS=0.1296p
+ AD=0.081p PS=1.52u PD=0.81u
M$1736 \$I4637 \$I4643 \$I4634 VGND sg13_lv_nmos L=0.13u W=0.42u AS=0.081p
+ AD=0.2163p PS=0.81u PD=1.87u
M$1737 VGND \$I4638 \$I4636 VGND sg13_lv_nmos L=0.13u W=0.64u AS=0.2176p
+ AD=0.2176p PS=1.96u PD=1.96u
M$1738 \$I4635 \$I4639 VGND VGND sg13_lv_nmos L=0.13u W=0.42u AS=0.1428p
+ AD=0.0798p PS=1.52u PD=0.8u
M$1739 VGND \$30 \$I4642 VGND sg13_lv_nmos L=0.13u W=0.42u AS=0.0798p
+ AD=0.0378p PS=0.8u PD=0.6u
M$1740 \$I4642 \$I4638 \$I4639 VGND sg13_lv_nmos L=0.13u W=0.42u AS=0.0378p
+ AD=0.1428p PS=0.6u PD=1.52u
M$1741 \$I4633 \$42 \$I4640 VGND sg13_lv_nmos L=0.13u W=0.42u AS=0.1428p
+ AD=0.0609p PS=1.52u PD=0.71u
M$1742 \$I4640 \$30 VGND VGND sg13_lv_nmos L=0.13u W=0.42u AS=0.0609p
+ AD=0.1626p PS=0.71u PD=1.415u
M$1743 VGND \$I4637 \$I4631 VGND sg13_lv_nmos L=0.13u W=0.74u AS=0.1626p
+ AD=0.2516p PS=1.415u PD=2.16u
M$1744 VGND \$30 \$I4641 VGND sg13_lv_nmos L=0.13u W=0.42u AS=0.1701p
+ AD=0.03885p PS=1.65u PD=0.605u
M$1745 \$I4641 \$I4631 \$I4634 VGND sg13_lv_nmos L=0.13u W=0.42u AS=0.03885p
+ AD=0.1596p PS=0.605u PD=1.6u
M$1746 \$I4637 \$30 VPWR VPWR sg13_lv_pmos L=0.13u W=0.42u AS=0.147p AD=0.1563p
+ PS=1.54u PD=1.22u
M$1747 VPWR \$I4631 \$I4644 VPWR sg13_lv_pmos L=0.13u W=0.42u AS=0.1563p
+ AD=0.0546p PS=1.22u PD=0.68u
M$1748 \$I4644 \$I4632 \$I4637 VPWR sg13_lv_pmos L=0.13u W=0.42u AS=0.0546p
+ AD=0.0798p PS=0.68u PD=0.8u
M$1749 \$I4637 \$I4643 \$I4633 VPWR sg13_lv_pmos L=0.13u W=0.42u AS=0.0798p
+ AD=0.1428p PS=0.8u PD=1.52u
M$1750 \$I4643 \$I4632 VPWR VPWR sg13_lv_pmos L=0.13u W=1.12u AS=0.3864p
+ AD=0.431025p PS=2.93u PD=2.145u
M$1751 VPWR \$52 \$I4632 VPWR sg13_lv_pmos L=0.13u W=1.12u AS=0.431025p
+ AD=0.3808p PS=2.145u PD=2.92u
M$1752 VPWR \$I4636 \$18 VPWR sg13_lv_pmos L=0.13u W=2.24u AS=0.5964p
+ AD=0.5964p PS=4.425u PD=4.425u
M$1754 VPWR \$42 \$I4633 VPWR sg13_lv_pmos L=0.13u W=0.42u AS=0.1428p
+ AD=0.0798p PS=1.52u PD=0.8u
M$1755 VPWR \$30 \$I4633 VPWR sg13_lv_pmos L=0.13u W=0.42u AS=0.3623875p
+ AD=0.0798p PS=2.605u PD=0.8u
M$1756 VPWR \$I4637 \$I4631 VPWR sg13_lv_pmos L=0.13u W=1u AS=0.3623875p
+ AD=0.34p PS=2.605u PD=2.68u
M$1757 \$I4638 \$I4643 \$I4645 VPWR sg13_lv_pmos L=0.13u W=0.42u AS=0.19115p
+ AD=0.0525p PS=1.565u PD=0.67u
M$1758 \$I4645 \$I4639 VPWR VPWR sg13_lv_pmos L=0.13u W=0.42u AS=0.0525p
+ AD=0.25605p PS=0.67u PD=1.935u
M$1759 VPWR \$30 \$I4639 VPWR sg13_lv_pmos L=0.13u W=0.42u AS=0.25605p
+ AD=0.0798p PS=1.935u PD=0.8u
M$1760 \$I4639 \$I4638 VPWR VPWR sg13_lv_pmos L=0.13u W=0.42u AS=0.0798p
+ AD=0.26795p PS=0.8u PD=1.895u
M$1761 \$I4631 \$I4632 \$I4638 VPWR sg13_lv_pmos L=0.13u W=1u AS=0.34p
+ AD=0.19115p PS=2.68u PD=1.565u
M$1762 VPWR \$I4638 \$I4636 VPWR sg13_lv_pmos L=0.13u W=1u AS=0.26795p AD=0.34p
+ PS=1.895u PD=2.68u
M$1763 VGND \$I4651 \$165 VGND sg13_lv_nmos L=0.13u W=1.48u AS=0.39405p
+ AD=0.39405p PS=3.285u PD=3.285u
M$1765 \$I4653 \$I4647 \$I4650 VGND sg13_lv_nmos L=0.13u W=0.42u AS=0.12665p
+ AD=0.1428p PS=1.145u PD=1.52u
M$1766 \$I4646 \$I4658 \$I4653 VGND sg13_lv_nmos L=0.13u W=0.74u AS=0.3473p
+ AD=0.12665p PS=2.71u PD=1.145u
M$1767 VGND \$I4647 \$I4658 VGND sg13_lv_nmos L=0.13u W=0.74u AS=0.43315p
+ AD=0.2516p PS=2.205u PD=2.16u
M$1768 VGND \$52 \$I4647 VGND sg13_lv_nmos L=0.13u W=0.74u AS=0.43315p
+ AD=0.2516p PS=2.205u PD=2.16u
M$1769 \$I4648 \$I4647 \$I4652 VGND sg13_lv_nmos L=0.13u W=0.42u AS=0.1296p
+ AD=0.081p PS=1.52u PD=0.81u
M$1770 \$I4652 \$I4658 \$I4649 VGND sg13_lv_nmos L=0.13u W=0.42u AS=0.081p
+ AD=0.2163p PS=0.81u PD=1.87u
M$1771 VGND \$I4653 \$I4651 VGND sg13_lv_nmos L=0.13u W=0.64u AS=0.2176p
+ AD=0.2176p PS=1.96u PD=1.96u
M$1772 \$I4650 \$I4654 VGND VGND sg13_lv_nmos L=0.13u W=0.42u AS=0.1428p
+ AD=0.0798p PS=1.52u PD=0.8u
M$1773 VGND \$154 \$I4657 VGND sg13_lv_nmos L=0.13u W=0.42u AS=0.0798p
+ AD=0.0378p PS=0.8u PD=0.6u
M$1774 \$I4657 \$I4653 \$I4654 VGND sg13_lv_nmos L=0.13u W=0.42u AS=0.0378p
+ AD=0.1428p PS=0.6u PD=1.52u
M$1775 \$I4648 \$86 \$I4655 VGND sg13_lv_nmos L=0.13u W=0.42u AS=0.1428p
+ AD=0.0609p PS=1.52u PD=0.71u
M$1776 \$I4655 \$154 VGND VGND sg13_lv_nmos L=0.13u W=0.42u AS=0.0609p
+ AD=0.1626p PS=0.71u PD=1.415u
M$1777 VGND \$I4652 \$I4646 VGND sg13_lv_nmos L=0.13u W=0.74u AS=0.1626p
+ AD=0.2516p PS=1.415u PD=2.16u
M$1778 VGND \$154 \$I4656 VGND sg13_lv_nmos L=0.13u W=0.42u AS=0.1701p
+ AD=0.03885p PS=1.65u PD=0.605u
M$1779 \$I4656 \$I4646 \$I4649 VGND sg13_lv_nmos L=0.13u W=0.42u AS=0.03885p
+ AD=0.1596p PS=0.605u PD=1.6u
M$1780 \$I4652 \$154 VPWR VPWR sg13_lv_pmos L=0.13u W=0.42u AS=0.147p
+ AD=0.1563p PS=1.54u PD=1.22u
M$1781 VPWR \$I4646 \$I4659 VPWR sg13_lv_pmos L=0.13u W=0.42u AS=0.1563p
+ AD=0.0546p PS=1.22u PD=0.68u
M$1782 \$I4659 \$I4647 \$I4652 VPWR sg13_lv_pmos L=0.13u W=0.42u AS=0.0546p
+ AD=0.0798p PS=0.68u PD=0.8u
M$1783 \$I4652 \$I4658 \$I4648 VPWR sg13_lv_pmos L=0.13u W=0.42u AS=0.0798p
+ AD=0.1428p PS=0.8u PD=1.52u
M$1784 \$I4658 \$I4647 VPWR VPWR sg13_lv_pmos L=0.13u W=1.12u AS=0.3864p
+ AD=0.431025p PS=2.93u PD=2.145u
M$1785 VPWR \$52 \$I4647 VPWR sg13_lv_pmos L=0.13u W=1.12u AS=0.431025p
+ AD=0.3808p PS=2.145u PD=2.92u
M$1786 VPWR \$I4651 \$165 VPWR sg13_lv_pmos L=0.13u W=2.24u AS=0.5964p
+ AD=0.5964p PS=4.425u PD=4.425u
M$1788 VPWR \$86 \$I4648 VPWR sg13_lv_pmos L=0.13u W=0.42u AS=0.1428p
+ AD=0.0798p PS=1.52u PD=0.8u
M$1789 VPWR \$154 \$I4648 VPWR sg13_lv_pmos L=0.13u W=0.42u AS=0.3623875p
+ AD=0.0798p PS=2.605u PD=0.8u
M$1790 VPWR \$I4652 \$I4646 VPWR sg13_lv_pmos L=0.13u W=1u AS=0.3623875p
+ AD=0.34p PS=2.605u PD=2.68u
M$1791 \$I4653 \$I4658 \$I4660 VPWR sg13_lv_pmos L=0.13u W=0.42u AS=0.19115p
+ AD=0.0525p PS=1.565u PD=0.67u
M$1792 \$I4660 \$I4654 VPWR VPWR sg13_lv_pmos L=0.13u W=0.42u AS=0.0525p
+ AD=0.25605p PS=0.67u PD=1.935u
M$1793 VPWR \$154 \$I4654 VPWR sg13_lv_pmos L=0.13u W=0.42u AS=0.25605p
+ AD=0.0798p PS=1.935u PD=0.8u
M$1794 \$I4654 \$I4653 VPWR VPWR sg13_lv_pmos L=0.13u W=0.42u AS=0.0798p
+ AD=0.26795p PS=0.8u PD=1.895u
M$1795 \$I4646 \$I4647 \$I4653 VPWR sg13_lv_pmos L=0.13u W=1u AS=0.34p
+ AD=0.19115p PS=2.68u PD=1.565u
M$1796 VPWR \$I4653 \$I4651 VPWR sg13_lv_pmos L=0.13u W=1u AS=0.26795p AD=0.34p
+ PS=1.895u PD=2.68u
M$1797 VGND \$I4666 \$397 VGND sg13_lv_nmos L=0.13u W=1.48u AS=0.39405p
+ AD=0.39405p PS=3.285u PD=3.285u
M$1799 \$I4668 \$I4662 \$I4665 VGND sg13_lv_nmos L=0.13u W=0.42u AS=0.12665p
+ AD=0.1428p PS=1.145u PD=1.52u
M$1800 \$I4661 \$I4673 \$I4668 VGND sg13_lv_nmos L=0.13u W=0.74u AS=0.3473p
+ AD=0.12665p PS=2.71u PD=1.145u
M$1801 VGND \$I4662 \$I4673 VGND sg13_lv_nmos L=0.13u W=0.74u AS=0.43315p
+ AD=0.2516p PS=2.205u PD=2.16u
M$1802 VGND \$52 \$I4662 VGND sg13_lv_nmos L=0.13u W=0.74u AS=0.43315p
+ AD=0.2516p PS=2.205u PD=2.16u
M$1803 \$I4663 \$I4662 \$I4667 VGND sg13_lv_nmos L=0.13u W=0.42u AS=0.1296p
+ AD=0.081p PS=1.52u PD=0.81u
M$1804 \$I4667 \$I4673 \$I4664 VGND sg13_lv_nmos L=0.13u W=0.42u AS=0.081p
+ AD=0.2163p PS=0.81u PD=1.87u
M$1805 VGND \$I4668 \$I4666 VGND sg13_lv_nmos L=0.13u W=0.64u AS=0.2176p
+ AD=0.2176p PS=1.96u PD=1.96u
M$1806 \$I4665 \$I4669 VGND VGND sg13_lv_nmos L=0.13u W=0.42u AS=0.1428p
+ AD=0.0798p PS=1.52u PD=0.8u
M$1807 VGND \$454 \$I4672 VGND sg13_lv_nmos L=0.13u W=0.42u AS=0.0798p
+ AD=0.0378p PS=0.8u PD=0.6u
M$1808 \$I4672 \$I4668 \$I4669 VGND sg13_lv_nmos L=0.13u W=0.42u AS=0.0378p
+ AD=0.1428p PS=0.6u PD=1.52u
M$1809 \$I4663 \$352 \$I4670 VGND sg13_lv_nmos L=0.13u W=0.42u AS=0.1428p
+ AD=0.0609p PS=1.52u PD=0.71u
M$1810 \$I4670 \$454 VGND VGND sg13_lv_nmos L=0.13u W=0.42u AS=0.0609p
+ AD=0.1626p PS=0.71u PD=1.415u
M$1811 VGND \$I4667 \$I4661 VGND sg13_lv_nmos L=0.13u W=0.74u AS=0.1626p
+ AD=0.2516p PS=1.415u PD=2.16u
M$1812 VGND \$454 \$I4671 VGND sg13_lv_nmos L=0.13u W=0.42u AS=0.1701p
+ AD=0.03885p PS=1.65u PD=0.605u
M$1813 \$I4671 \$I4661 \$I4664 VGND sg13_lv_nmos L=0.13u W=0.42u AS=0.03885p
+ AD=0.1596p PS=0.605u PD=1.6u
M$1814 \$I4667 \$454 VPWR VPWR sg13_lv_pmos L=0.13u W=0.42u AS=0.147p
+ AD=0.1563p PS=1.54u PD=1.22u
M$1815 VPWR \$I4661 \$I4674 VPWR sg13_lv_pmos L=0.13u W=0.42u AS=0.1563p
+ AD=0.0546p PS=1.22u PD=0.68u
M$1816 \$I4674 \$I4662 \$I4667 VPWR sg13_lv_pmos L=0.13u W=0.42u AS=0.0546p
+ AD=0.0798p PS=0.68u PD=0.8u
M$1817 \$I4667 \$I4673 \$I4663 VPWR sg13_lv_pmos L=0.13u W=0.42u AS=0.0798p
+ AD=0.1428p PS=0.8u PD=1.52u
M$1818 \$I4673 \$I4662 VPWR VPWR sg13_lv_pmos L=0.13u W=1.12u AS=0.3864p
+ AD=0.431025p PS=2.93u PD=2.145u
M$1819 VPWR \$52 \$I4662 VPWR sg13_lv_pmos L=0.13u W=1.12u AS=0.431025p
+ AD=0.3808p PS=2.145u PD=2.92u
M$1820 VPWR \$I4666 \$397 VPWR sg13_lv_pmos L=0.13u W=2.24u AS=0.5964p
+ AD=0.5964p PS=4.425u PD=4.425u
M$1822 VPWR \$352 \$I4663 VPWR sg13_lv_pmos L=0.13u W=0.42u AS=0.1428p
+ AD=0.0798p PS=1.52u PD=0.8u
M$1823 VPWR \$454 \$I4663 VPWR sg13_lv_pmos L=0.13u W=0.42u AS=0.3623875p
+ AD=0.0798p PS=2.605u PD=0.8u
M$1824 VPWR \$I4667 \$I4661 VPWR sg13_lv_pmos L=0.13u W=1u AS=0.3623875p
+ AD=0.34p PS=2.605u PD=2.68u
M$1825 \$I4668 \$I4673 \$I4675 VPWR sg13_lv_pmos L=0.13u W=0.42u AS=0.19115p
+ AD=0.0525p PS=1.565u PD=0.67u
M$1826 \$I4675 \$I4669 VPWR VPWR sg13_lv_pmos L=0.13u W=0.42u AS=0.0525p
+ AD=0.25605p PS=0.67u PD=1.935u
M$1827 VPWR \$454 \$I4669 VPWR sg13_lv_pmos L=0.13u W=0.42u AS=0.25605p
+ AD=0.0798p PS=1.935u PD=0.8u
M$1828 \$I4669 \$I4668 VPWR VPWR sg13_lv_pmos L=0.13u W=0.42u AS=0.0798p
+ AD=0.26795p PS=0.8u PD=1.895u
M$1829 \$I4661 \$I4662 \$I4668 VPWR sg13_lv_pmos L=0.13u W=1u AS=0.34p
+ AD=0.19115p PS=2.68u PD=1.565u
M$1830 VPWR \$I4668 \$I4666 VPWR sg13_lv_pmos L=0.13u W=1u AS=0.26795p AD=0.34p
+ PS=1.895u PD=2.68u
M$1831 VGND \$I4681 \$600 VGND sg13_lv_nmos L=0.13u W=1.48u AS=0.39405p
+ AD=0.39405p PS=3.285u PD=3.285u
M$1833 \$I4683 \$I4677 \$I4680 VGND sg13_lv_nmos L=0.13u W=0.42u AS=0.12665p
+ AD=0.1428p PS=1.145u PD=1.52u
M$1834 \$I4676 \$I4688 \$I4683 VGND sg13_lv_nmos L=0.13u W=0.74u AS=0.3473p
+ AD=0.12665p PS=2.71u PD=1.145u
M$1835 VGND \$I4677 \$I4688 VGND sg13_lv_nmos L=0.13u W=0.74u AS=0.43315p
+ AD=0.2516p PS=2.205u PD=2.16u
M$1836 VGND \$587 \$I4677 VGND sg13_lv_nmos L=0.13u W=0.74u AS=0.43315p
+ AD=0.2516p PS=2.205u PD=2.16u
M$1837 \$I4678 \$I4677 \$I4682 VGND sg13_lv_nmos L=0.13u W=0.42u AS=0.1296p
+ AD=0.081p PS=1.52u PD=0.81u
M$1838 \$I4682 \$I4688 \$I4679 VGND sg13_lv_nmos L=0.13u W=0.42u AS=0.081p
+ AD=0.2163p PS=0.81u PD=1.87u
M$1839 VGND \$I4683 \$I4681 VGND sg13_lv_nmos L=0.13u W=0.64u AS=0.2176p
+ AD=0.2176p PS=1.96u PD=1.96u
M$1840 \$I4680 \$I4684 VGND VGND sg13_lv_nmos L=0.13u W=0.42u AS=0.1428p
+ AD=0.0798p PS=1.52u PD=0.8u
M$1841 VGND \$478 \$I4687 VGND sg13_lv_nmos L=0.13u W=0.42u AS=0.0798p
+ AD=0.0378p PS=0.8u PD=0.6u
M$1842 \$I4687 \$I4683 \$I4684 VGND sg13_lv_nmos L=0.13u W=0.42u AS=0.0378p
+ AD=0.1428p PS=0.6u PD=1.52u
M$1843 \$I4678 \$678 \$I4685 VGND sg13_lv_nmos L=0.13u W=0.42u AS=0.1428p
+ AD=0.0609p PS=1.52u PD=0.71u
M$1844 \$I4685 \$478 VGND VGND sg13_lv_nmos L=0.13u W=0.42u AS=0.0609p
+ AD=0.1626p PS=0.71u PD=1.415u
M$1845 VGND \$I4682 \$I4676 VGND sg13_lv_nmos L=0.13u W=0.74u AS=0.1626p
+ AD=0.2516p PS=1.415u PD=2.16u
M$1846 VGND \$478 \$I4686 VGND sg13_lv_nmos L=0.13u W=0.42u AS=0.1701p
+ AD=0.03885p PS=1.65u PD=0.605u
M$1847 \$I4686 \$I4676 \$I4679 VGND sg13_lv_nmos L=0.13u W=0.42u AS=0.03885p
+ AD=0.1596p PS=0.605u PD=1.6u
M$1848 \$I4682 \$478 VPWR VPWR sg13_lv_pmos L=0.13u W=0.42u AS=0.147p
+ AD=0.1563p PS=1.54u PD=1.22u
M$1849 VPWR \$I4676 \$I4689 VPWR sg13_lv_pmos L=0.13u W=0.42u AS=0.1563p
+ AD=0.0546p PS=1.22u PD=0.68u
M$1850 \$I4689 \$I4677 \$I4682 VPWR sg13_lv_pmos L=0.13u W=0.42u AS=0.0546p
+ AD=0.0798p PS=0.68u PD=0.8u
M$1851 \$I4682 \$I4688 \$I4678 VPWR sg13_lv_pmos L=0.13u W=0.42u AS=0.0798p
+ AD=0.1428p PS=0.8u PD=1.52u
M$1852 \$I4688 \$I4677 VPWR VPWR sg13_lv_pmos L=0.13u W=1.12u AS=0.3864p
+ AD=0.431025p PS=2.93u PD=2.145u
M$1853 VPWR \$587 \$I4677 VPWR sg13_lv_pmos L=0.13u W=1.12u AS=0.431025p
+ AD=0.3808p PS=2.145u PD=2.92u
M$1854 VPWR \$I4681 \$600 VPWR sg13_lv_pmos L=0.13u W=2.24u AS=0.5964p
+ AD=0.5964p PS=4.425u PD=4.425u
M$1856 VPWR \$678 \$I4678 VPWR sg13_lv_pmos L=0.13u W=0.42u AS=0.1428p
+ AD=0.0798p PS=1.52u PD=0.8u
M$1857 VPWR \$478 \$I4678 VPWR sg13_lv_pmos L=0.13u W=0.42u AS=0.3623875p
+ AD=0.0798p PS=2.605u PD=0.8u
M$1858 VPWR \$I4682 \$I4676 VPWR sg13_lv_pmos L=0.13u W=1u AS=0.3623875p
+ AD=0.34p PS=2.605u PD=2.68u
M$1859 \$I4683 \$I4688 \$I4690 VPWR sg13_lv_pmos L=0.13u W=0.42u AS=0.19115p
+ AD=0.0525p PS=1.565u PD=0.67u
M$1860 \$I4690 \$I4684 VPWR VPWR sg13_lv_pmos L=0.13u W=0.42u AS=0.0525p
+ AD=0.25605p PS=0.67u PD=1.935u
M$1861 VPWR \$478 \$I4684 VPWR sg13_lv_pmos L=0.13u W=0.42u AS=0.25605p
+ AD=0.0798p PS=1.935u PD=0.8u
M$1862 \$I4684 \$I4683 VPWR VPWR sg13_lv_pmos L=0.13u W=0.42u AS=0.0798p
+ AD=0.26795p PS=0.8u PD=1.895u
M$1863 \$I4676 \$I4677 \$I4683 VPWR sg13_lv_pmos L=0.13u W=1u AS=0.34p
+ AD=0.19115p PS=2.68u PD=1.565u
M$1864 VPWR \$I4683 \$I4681 VPWR sg13_lv_pmos L=0.13u W=1u AS=0.26795p AD=0.34p
+ PS=1.895u PD=2.68u
M$1865 VGND \$I4693 \$I4693 VGND sg13_lv_nmos L=0.13u W=0.3u AS=0.2043375p
+ AD=0.111p PS=1.585u PD=1.34u
M$1866 VGND \$I4692 \$I4691 VGND sg13_lv_nmos L=0.13u W=0.795u AS=0.2043375p
+ AD=0.274275p PS=1.585u PD=2.28u
M$1867 \$I4692 \$I4693 VPWR VPWR sg13_lv_pmos L=0.13u W=0.66u AS=0.2442p
+ AD=0.4657125p PS=2.06u PD=2.54u
M$1868 VPWR \$I4691 \$22 VPWR sg13_lv_pmos L=0.13u W=1.155u AS=0.4657125p
+ AD=0.3927p PS=2.54u PD=2.99u
M$1869 VGND \$I4696 \$I4696 VGND sg13_lv_nmos L=0.13u W=0.3u AS=0.2043375p
+ AD=0.111p PS=1.585u PD=1.34u
M$1870 VGND \$I4695 \$I4694 VGND sg13_lv_nmos L=0.13u W=0.795u AS=0.2043375p
+ AD=0.274275p PS=1.585u PD=2.28u
M$1871 \$I4695 \$I4696 VPWR VPWR sg13_lv_pmos L=0.13u W=0.66u AS=0.2442p
+ AD=0.4657125p PS=2.06u PD=2.54u
M$1872 VPWR \$I4694 \$30 VPWR sg13_lv_pmos L=0.13u W=1.155u AS=0.4657125p
+ AD=0.3927p PS=2.54u PD=2.99u
M$1873 VGND \$I4699 \$I4699 VGND sg13_lv_nmos L=0.13u W=0.3u AS=0.2043375p
+ AD=0.111p PS=1.585u PD=1.34u
M$1874 VGND \$I4698 \$I4697 VGND sg13_lv_nmos L=0.13u W=0.795u AS=0.2043375p
+ AD=0.274275p PS=1.585u PD=2.28u
M$1875 \$I4698 \$I4699 VPWR VPWR sg13_lv_pmos L=0.13u W=0.66u AS=0.2442p
+ AD=0.4657125p PS=2.06u PD=2.54u
M$1876 VPWR \$I4697 \$128 VPWR sg13_lv_pmos L=0.13u W=1.155u AS=0.4657125p
+ AD=0.3927p PS=2.54u PD=2.99u
M$1877 VGND \$I4702 \$I4702 VGND sg13_lv_nmos L=0.13u W=0.3u AS=0.2043375p
+ AD=0.111p PS=1.585u PD=1.34u
M$1878 VGND \$I4701 \$I4700 VGND sg13_lv_nmos L=0.13u W=0.795u AS=0.2043375p
+ AD=0.274275p PS=1.585u PD=2.28u
M$1879 \$I4701 \$I4702 VPWR VPWR sg13_lv_pmos L=0.13u W=0.66u AS=0.2442p
+ AD=0.4657125p PS=2.06u PD=2.54u
M$1880 VPWR \$I4700 \$146 VPWR sg13_lv_pmos L=0.13u W=1.155u AS=0.4657125p
+ AD=0.3927p PS=2.54u PD=2.99u
M$1881 VGND \$I4705 \$I4705 VGND sg13_lv_nmos L=0.13u W=0.3u AS=0.2043375p
+ AD=0.111p PS=1.585u PD=1.34u
M$1882 VGND \$I4704 \$I4703 VGND sg13_lv_nmos L=0.13u W=0.795u AS=0.2043375p
+ AD=0.274275p PS=1.585u PD=2.28u
M$1883 \$I4704 \$I4705 VPWR VPWR sg13_lv_pmos L=0.13u W=0.66u AS=0.2442p
+ AD=0.4657125p PS=2.06u PD=2.54u
M$1884 VPWR \$I4703 \$24 VPWR sg13_lv_pmos L=0.13u W=1.155u AS=0.4657125p
+ AD=0.3927p PS=2.54u PD=2.99u
M$1885 VGND \$I4708 \$I4708 VGND sg13_lv_nmos L=0.13u W=0.3u AS=0.2043375p
+ AD=0.111p PS=1.585u PD=1.34u
M$1886 VGND \$I4707 \$I4706 VGND sg13_lv_nmos L=0.13u W=0.795u AS=0.2043375p
+ AD=0.274275p PS=1.585u PD=2.28u
M$1887 \$I4707 \$I4708 VPWR VPWR sg13_lv_pmos L=0.13u W=0.66u AS=0.2442p
+ AD=0.4657125p PS=2.06u PD=2.54u
M$1888 VPWR \$I4706 \$89 VPWR sg13_lv_pmos L=0.13u W=1.155u AS=0.4657125p
+ AD=0.3927p PS=2.54u PD=2.99u
M$1889 VGND \$I4711 \$I4711 VGND sg13_lv_nmos L=0.13u W=0.3u AS=0.2043375p
+ AD=0.111p PS=1.585u PD=1.34u
M$1890 VGND \$I4710 \$I4709 VGND sg13_lv_nmos L=0.13u W=0.795u AS=0.2043375p
+ AD=0.274275p PS=1.585u PD=2.28u
M$1891 \$I4710 \$I4711 VPWR VPWR sg13_lv_pmos L=0.13u W=0.66u AS=0.2442p
+ AD=0.4657125p PS=2.06u PD=2.54u
M$1892 VPWR \$I4709 \$154 VPWR sg13_lv_pmos L=0.13u W=1.155u AS=0.4657125p
+ AD=0.3927p PS=2.54u PD=2.99u
M$1893 VGND \$I4714 \$I4714 VGND sg13_lv_nmos L=0.13u W=0.3u AS=0.2043375p
+ AD=0.111p PS=1.585u PD=1.34u
M$1894 VGND \$I4713 \$I4712 VGND sg13_lv_nmos L=0.13u W=0.795u AS=0.2043375p
+ AD=0.274275p PS=1.585u PD=2.28u
M$1895 \$I4713 \$I4714 VPWR VPWR sg13_lv_pmos L=0.13u W=0.66u AS=0.2442p
+ AD=0.4657125p PS=2.06u PD=2.54u
M$1896 VPWR \$I4712 \$189 VPWR sg13_lv_pmos L=0.13u W=1.155u AS=0.4657125p
+ AD=0.3927p PS=2.54u PD=2.99u
M$1897 VGND \$I4717 \$I4717 VGND sg13_lv_nmos L=0.13u W=0.3u AS=0.2043375p
+ AD=0.111p PS=1.585u PD=1.34u
M$1898 VGND \$I4716 \$I4715 VGND sg13_lv_nmos L=0.13u W=0.795u AS=0.2043375p
+ AD=0.274275p PS=1.585u PD=2.28u
M$1899 \$I4716 \$I4717 VPWR VPWR sg13_lv_pmos L=0.13u W=0.66u AS=0.2442p
+ AD=0.4657125p PS=2.06u PD=2.54u
M$1900 VPWR \$I4715 \$138 VPWR sg13_lv_pmos L=0.13u W=1.155u AS=0.4657125p
+ AD=0.3927p PS=2.54u PD=2.99u
M$1901 VGND \$I4720 \$I4720 VGND sg13_lv_nmos L=0.13u W=0.3u AS=0.2043375p
+ AD=0.111p PS=1.585u PD=1.34u
M$1902 VGND \$I4719 \$I4718 VGND sg13_lv_nmos L=0.13u W=0.795u AS=0.2043375p
+ AD=0.274275p PS=1.585u PD=2.28u
M$1903 \$I4719 \$I4720 VPWR VPWR sg13_lv_pmos L=0.13u W=0.66u AS=0.2442p
+ AD=0.4657125p PS=2.06u PD=2.54u
M$1904 VPWR \$I4718 \$337 VPWR sg13_lv_pmos L=0.13u W=1.155u AS=0.4657125p
+ AD=0.3927p PS=2.54u PD=2.99u
M$1905 VGND \$I4723 \$I4723 VGND sg13_lv_nmos L=0.13u W=0.3u AS=0.2043375p
+ AD=0.111p PS=1.585u PD=1.34u
M$1906 VGND \$I4722 \$I4721 VGND sg13_lv_nmos L=0.13u W=0.795u AS=0.2043375p
+ AD=0.274275p PS=1.585u PD=2.28u
M$1907 \$I4722 \$I4723 VPWR VPWR sg13_lv_pmos L=0.13u W=0.66u AS=0.2442p
+ AD=0.4657125p PS=2.06u PD=2.54u
M$1908 VPWR \$I4721 \$401 VPWR sg13_lv_pmos L=0.13u W=1.155u AS=0.4657125p
+ AD=0.3927p PS=2.54u PD=2.99u
M$1909 VGND \$I4726 \$I4726 VGND sg13_lv_nmos L=0.13u W=0.3u AS=0.2043375p
+ AD=0.111p PS=1.585u PD=1.34u
M$1910 VGND \$I4725 \$I4724 VGND sg13_lv_nmos L=0.13u W=0.795u AS=0.2043375p
+ AD=0.274275p PS=1.585u PD=2.28u
M$1911 \$I4725 \$I4726 VPWR VPWR sg13_lv_pmos L=0.13u W=0.66u AS=0.2442p
+ AD=0.4657125p PS=2.06u PD=2.54u
M$1912 VPWR \$I4724 \$340 VPWR sg13_lv_pmos L=0.13u W=1.155u AS=0.4657125p
+ AD=0.3927p PS=2.54u PD=2.99u
M$1913 VGND \$I4729 \$I4729 VGND sg13_lv_nmos L=0.13u W=0.3u AS=0.2043375p
+ AD=0.111p PS=1.585u PD=1.34u
M$1914 VGND \$I4728 \$I4727 VGND sg13_lv_nmos L=0.13u W=0.795u AS=0.2043375p
+ AD=0.274275p PS=1.585u PD=2.28u
M$1915 \$I4728 \$I4729 VPWR VPWR sg13_lv_pmos L=0.13u W=0.66u AS=0.2442p
+ AD=0.4657125p PS=2.06u PD=2.54u
M$1916 VPWR \$I4727 \$478 VPWR sg13_lv_pmos L=0.13u W=1.155u AS=0.4657125p
+ AD=0.3927p PS=2.54u PD=2.99u
M$1917 VGND \$I4732 \$I4732 VGND sg13_lv_nmos L=0.13u W=0.3u AS=0.2043375p
+ AD=0.111p PS=1.585u PD=1.34u
M$1918 VGND \$I4731 \$I4730 VGND sg13_lv_nmos L=0.13u W=0.795u AS=0.2043375p
+ AD=0.274275p PS=1.585u PD=2.28u
M$1919 \$I4731 \$I4732 VPWR VPWR sg13_lv_pmos L=0.13u W=0.66u AS=0.2442p
+ AD=0.4657125p PS=2.06u PD=2.54u
M$1920 VPWR \$I4730 \$454 VPWR sg13_lv_pmos L=0.13u W=1.155u AS=0.4657125p
+ AD=0.3927p PS=2.54u PD=2.99u
M$1921 VGND \$I4735 \$I4735 VGND sg13_lv_nmos L=0.13u W=0.3u AS=0.2043375p
+ AD=0.111p PS=1.585u PD=1.34u
M$1922 VGND \$I4734 \$I4733 VGND sg13_lv_nmos L=0.13u W=0.795u AS=0.2043375p
+ AD=0.274275p PS=1.585u PD=2.28u
M$1923 \$I4734 \$I4735 VPWR VPWR sg13_lv_pmos L=0.13u W=0.66u AS=0.2442p
+ AD=0.4657125p PS=2.06u PD=2.54u
M$1924 VPWR \$I4733 \$622 VPWR sg13_lv_pmos L=0.13u W=1.155u AS=0.4657125p
+ AD=0.3927p PS=2.54u PD=2.99u
M$1925 VGND \$I4738 \$I4738 VGND sg13_lv_nmos L=0.13u W=0.3u AS=0.2043375p
+ AD=0.111p PS=1.585u PD=1.34u
M$1926 VGND \$I4737 \$I4736 VGND sg13_lv_nmos L=0.13u W=0.795u AS=0.2043375p
+ AD=0.274275p PS=1.585u PD=2.28u
M$1927 \$I4737 \$I4738 VPWR VPWR sg13_lv_pmos L=0.13u W=0.66u AS=0.2442p
+ AD=0.4657125p PS=2.06u PD=2.54u
M$1928 VPWR \$I4736 \$550 VPWR sg13_lv_pmos L=0.13u W=1.155u AS=0.4657125p
+ AD=0.3927p PS=2.54u PD=2.99u
M$1929 VGND \$I4741 \$I4741 VGND sg13_lv_nmos L=0.13u W=0.3u AS=0.2043375p
+ AD=0.111p PS=1.585u PD=1.34u
M$1930 VGND \$I4740 \$I4739 VGND sg13_lv_nmos L=0.13u W=0.795u AS=0.2043375p
+ AD=0.274275p PS=1.585u PD=2.28u
M$1931 \$I4740 \$I4741 VPWR VPWR sg13_lv_pmos L=0.13u W=0.66u AS=0.2442p
+ AD=0.4657125p PS=2.06u PD=2.54u
M$1932 VPWR \$I4739 \$786 VPWR sg13_lv_pmos L=0.13u W=1.155u AS=0.4657125p
+ AD=0.3927p PS=2.54u PD=2.99u
M$1933 VGND \$I4744 \$I4744 VGND sg13_lv_nmos L=0.13u W=0.3u AS=0.2043375p
+ AD=0.111p PS=1.585u PD=1.34u
M$1934 VGND \$I4743 \$I4742 VGND sg13_lv_nmos L=0.13u W=0.795u AS=0.2043375p
+ AD=0.274275p PS=1.585u PD=2.28u
M$1935 \$I4743 \$I4744 VPWR VPWR sg13_lv_pmos L=0.13u W=0.66u AS=0.2442p
+ AD=0.4657125p PS=2.06u PD=2.54u
M$1936 VPWR \$I4742 \$801 VPWR sg13_lv_pmos L=0.13u W=1.155u AS=0.4657125p
+ AD=0.3927p PS=2.54u PD=2.99u
M$1937 VGND \$I4747 \$I4747 VGND sg13_lv_nmos L=0.13u W=0.3u AS=0.2043375p
+ AD=0.111p PS=1.585u PD=1.34u
M$1938 VGND \$I4746 \$I4745 VGND sg13_lv_nmos L=0.13u W=0.795u AS=0.2043375p
+ AD=0.274275p PS=1.585u PD=2.28u
M$1939 \$I4746 \$I4747 VPWR VPWR sg13_lv_pmos L=0.13u W=0.66u AS=0.2442p
+ AD=0.4657125p PS=2.06u PD=2.54u
M$1940 VPWR \$I4745 \$666 VPWR sg13_lv_pmos L=0.13u W=1.155u AS=0.4657125p
+ AD=0.3927p PS=2.54u PD=2.99u
M$1941 VGND \$I4750 \$I4750 VGND sg13_lv_nmos L=0.13u W=0.3u AS=0.2043375p
+ AD=0.111p PS=1.585u PD=1.34u
M$1942 VGND \$I4749 \$I4748 VGND sg13_lv_nmos L=0.13u W=0.795u AS=0.2043375p
+ AD=0.274275p PS=1.585u PD=2.28u
M$1943 \$I4749 \$I4750 VPWR VPWR sg13_lv_pmos L=0.13u W=0.66u AS=0.2442p
+ AD=0.4657125p PS=2.06u PD=2.54u
M$1944 VPWR \$I4748 \$845 VPWR sg13_lv_pmos L=0.13u W=1.155u AS=0.4657125p
+ AD=0.3927p PS=2.54u PD=2.99u
M$1945 VGND \$I4753 \$I4753 VGND sg13_lv_nmos L=0.13u W=0.3u AS=0.2043375p
+ AD=0.111p PS=1.585u PD=1.34u
M$1946 VGND \$I4752 \$I4751 VGND sg13_lv_nmos L=0.13u W=0.795u AS=0.2043375p
+ AD=0.274275p PS=1.585u PD=2.28u
M$1947 \$I4752 \$I4753 VPWR VPWR sg13_lv_pmos L=0.13u W=0.66u AS=0.2442p
+ AD=0.4657125p PS=2.06u PD=2.54u
M$1948 VPWR \$I4751 \$832 VPWR sg13_lv_pmos L=0.13u W=1.155u AS=0.4657125p
+ AD=0.3927p PS=2.54u PD=2.99u
M$1949 VGND \$I4756 \$I4756 VGND sg13_lv_nmos L=0.13u W=0.3u AS=0.2043375p
+ AD=0.111p PS=1.585u PD=1.34u
M$1950 VGND \$I4755 \$I4754 VGND sg13_lv_nmos L=0.13u W=0.795u AS=0.2043375p
+ AD=0.274275p PS=1.585u PD=2.28u
M$1951 \$I4755 \$I4756 VPWR VPWR sg13_lv_pmos L=0.13u W=0.66u AS=0.2442p
+ AD=0.4657125p PS=2.06u PD=2.54u
M$1952 VPWR \$I4754 \$797 VPWR sg13_lv_pmos L=0.13u W=1.155u AS=0.4657125p
+ AD=0.3927p PS=2.54u PD=2.99u
M$1953 VGND \$I4759 \$I4759 VGND sg13_lv_nmos L=0.13u W=0.3u AS=0.2043375p
+ AD=0.111p PS=1.585u PD=1.34u
M$1954 VGND \$I4758 \$I4757 VGND sg13_lv_nmos L=0.13u W=0.795u AS=0.2043375p
+ AD=0.274275p PS=1.585u PD=2.28u
M$1955 \$I4758 \$I4759 VPWR VPWR sg13_lv_pmos L=0.13u W=0.66u AS=0.2442p
+ AD=0.4657125p PS=2.06u PD=2.54u
M$1956 VPWR \$I4757 \$495 VPWR sg13_lv_pmos L=0.13u W=1.155u AS=0.4657125p
+ AD=0.3927p PS=2.54u PD=2.99u
M$1957 VGND \$I4762 \$I4762 VGND sg13_lv_nmos L=0.13u W=0.3u AS=0.2043375p
+ AD=0.111p PS=1.585u PD=1.34u
M$1958 VGND \$I4761 \$I4760 VGND sg13_lv_nmos L=0.13u W=0.795u AS=0.2043375p
+ AD=0.274275p PS=1.585u PD=2.28u
M$1959 \$I4761 \$I4762 VPWR VPWR sg13_lv_pmos L=0.13u W=0.66u AS=0.2442p
+ AD=0.4657125p PS=2.06u PD=2.54u
M$1960 VPWR \$I4760 \$816 VPWR sg13_lv_pmos L=0.13u W=1.155u AS=0.4657125p
+ AD=0.3927p PS=2.54u PD=2.99u
M$1961 VGND \$I4765 \$I4765 VGND sg13_lv_nmos L=0.13u W=0.3u AS=0.2043375p
+ AD=0.111p PS=1.585u PD=1.34u
M$1962 VGND \$I4764 \$I4763 VGND sg13_lv_nmos L=0.13u W=0.795u AS=0.2043375p
+ AD=0.274275p PS=1.585u PD=2.28u
M$1963 \$I4764 \$I4765 VPWR VPWR sg13_lv_pmos L=0.13u W=0.66u AS=0.2442p
+ AD=0.4657125p PS=2.06u PD=2.54u
M$1964 VPWR \$I4763 \$857 VPWR sg13_lv_pmos L=0.13u W=1.155u AS=0.4657125p
+ AD=0.3927p PS=2.54u PD=2.99u
M$1965 VGND \$I4768 \$I4768 VGND sg13_lv_nmos L=0.13u W=0.3u AS=0.2043375p
+ AD=0.111p PS=1.585u PD=1.34u
M$1966 VGND \$I4767 \$I4766 VGND sg13_lv_nmos L=0.13u W=0.795u AS=0.2043375p
+ AD=0.274275p PS=1.585u PD=2.28u
M$1967 \$I4767 \$I4768 VPWR VPWR sg13_lv_pmos L=0.13u W=0.66u AS=0.2442p
+ AD=0.4657125p PS=2.06u PD=2.54u
M$1968 VPWR \$I4766 \$823 VPWR sg13_lv_pmos L=0.13u W=1.155u AS=0.4657125p
+ AD=0.3927p PS=2.54u PD=2.99u
M$1969 VGND \$I4771 \$I4771 VGND sg13_lv_nmos L=0.13u W=0.3u AS=0.2043375p
+ AD=0.111p PS=1.585u PD=1.34u
M$1970 VGND \$I4770 \$I4769 VGND sg13_lv_nmos L=0.13u W=0.795u AS=0.2043375p
+ AD=0.274275p PS=1.585u PD=2.28u
M$1971 \$I4770 \$I4771 VPWR VPWR sg13_lv_pmos L=0.13u W=0.66u AS=0.2442p
+ AD=0.4657125p PS=2.06u PD=2.54u
M$1972 VPWR \$I4769 \$895 VPWR sg13_lv_pmos L=0.13u W=1.155u AS=0.4657125p
+ AD=0.3927p PS=2.54u PD=2.99u
M$1973 VGND \$I4774 \$I4774 VGND sg13_lv_nmos L=0.13u W=0.3u AS=0.2043375p
+ AD=0.111p PS=1.585u PD=1.34u
M$1974 VGND \$I4773 \$I4772 VGND sg13_lv_nmos L=0.13u W=0.795u AS=0.2043375p
+ AD=0.274275p PS=1.585u PD=2.28u
M$1975 \$I4773 \$I4774 VPWR VPWR sg13_lv_pmos L=0.13u W=0.66u AS=0.2442p
+ AD=0.4657125p PS=2.06u PD=2.54u
M$1976 VPWR \$I4772 \$906 VPWR sg13_lv_pmos L=0.13u W=1.155u AS=0.4657125p
+ AD=0.3927p PS=2.54u PD=2.99u
M$1977 \$I4779 \$I4780 VGND VGND sg13_lv_nmos L=0.13u W=0.42u AS=0.1428p
+ AD=0.0798p PS=1.52u PD=0.8u
M$1978 VGND \$24 \$I4786 VGND sg13_lv_nmos L=0.13u W=0.42u AS=0.0798p
+ AD=0.0378p PS=0.8u PD=0.6u
M$1979 \$I4786 \$I4783 \$I4780 VGND sg13_lv_nmos L=0.13u W=0.42u AS=0.0378p
+ AD=0.1428p PS=0.6u PD=1.52u
M$1980 \$I4777 \$14 \$I4784 VGND sg13_lv_nmos L=0.13u W=0.42u AS=0.1428p
+ AD=0.0609p PS=1.52u PD=0.71u
M$1981 \$I4784 \$24 VGND VGND sg13_lv_nmos L=0.13u W=0.42u AS=0.0609p
+ AD=0.1626p PS=0.71u PD=1.415u
M$1982 VGND \$I4782 \$I4775 VGND sg13_lv_nmos L=0.13u W=0.74u AS=0.1626p
+ AD=0.2516p PS=1.415u PD=2.16u
M$1983 \$I4777 \$I4776 \$I4782 VGND sg13_lv_nmos L=0.13u W=0.42u AS=0.1296p
+ AD=0.0798p PS=1.52u PD=0.8u
M$1984 \$I4782 \$I4787 \$I4778 VGND sg13_lv_nmos L=0.13u W=0.42u AS=0.0798p
+ AD=0.2373p PS=0.8u PD=1.97u
M$1985 \$I4781 \$I4783 VGND VGND sg13_lv_nmos L=0.13u W=0.74u AS=0.2516p
+ AD=0.1406p PS=2.16u PD=1.12u
M$1986 VGND \$I4781 \$19 VGND sg13_lv_nmos L=0.13u W=0.74u AS=0.1406p
+ AD=0.2516p PS=1.12u PD=2.16u
M$1987 \$I4783 \$I4776 \$I4779 VGND sg13_lv_nmos L=0.13u W=0.42u AS=0.12665p
+ AD=0.1428p PS=1.145u PD=1.52u
M$1988 \$I4775 \$I4787 \$I4783 VGND sg13_lv_nmos L=0.13u W=0.74u AS=0.3473p
+ AD=0.12665p PS=2.71u PD=1.145u
M$1989 VGND \$24 \$I4785 VGND sg13_lv_nmos L=0.13u W=0.42u AS=0.1701p
+ AD=0.0378p PS=1.65u PD=0.6u
M$1990 \$I4785 \$I4775 \$I4778 VGND sg13_lv_nmos L=0.13u W=0.42u AS=0.0378p
+ AD=0.1428p PS=0.6u PD=1.52u
M$1991 VGND \$I4776 \$I4787 VGND sg13_lv_nmos L=0.13u W=0.74u AS=0.317325p
+ AD=0.2516p PS=1.805u PD=2.16u
M$1992 VGND \$15 \$I4776 VGND sg13_lv_nmos L=0.13u W=0.74u AS=0.317325p
+ AD=0.2516p PS=1.805u PD=2.16u
M$1993 \$I4782 \$24 VPWR VPWR sg13_lv_pmos L=0.13u W=0.42u AS=0.147p AD=0.1563p
+ PS=1.54u PD=1.22u
M$1994 VPWR \$I4775 \$I4788 VPWR sg13_lv_pmos L=0.13u W=0.42u AS=0.1563p
+ AD=0.063p PS=1.22u PD=0.72u
M$1995 \$I4788 \$I4776 \$I4782 VPWR sg13_lv_pmos L=0.13u W=0.42u AS=0.063p
+ AD=0.0798p PS=0.72u PD=0.8u
M$1996 \$I4782 \$I4787 \$I4777 VPWR sg13_lv_pmos L=0.13u W=0.42u AS=0.0798p
+ AD=0.1428p PS=0.8u PD=1.52u
M$1997 \$I4787 \$I4776 VPWR VPWR sg13_lv_pmos L=0.13u W=1.12u AS=0.3864p
+ AD=0.41165p PS=2.93u PD=2.12u
M$1998 VPWR \$15 \$I4776 VPWR sg13_lv_pmos L=0.13u W=1.12u AS=0.41165p
+ AD=0.4088p PS=2.12u PD=2.97u
M$1999 VPWR \$14 \$I4777 VPWR sg13_lv_pmos L=0.13u W=0.42u AS=0.1428p
+ AD=0.0798p PS=1.52u PD=0.8u
M$2000 VPWR \$24 \$I4777 VPWR sg13_lv_pmos L=0.13u W=0.42u AS=0.3623875p
+ AD=0.0798p PS=2.605u PD=0.8u
M$2001 VPWR \$I4782 \$I4775 VPWR sg13_lv_pmos L=0.13u W=1u AS=0.3623875p
+ AD=0.34p PS=2.605u PD=2.68u
M$2002 \$I4783 \$I4787 \$I4789 VPWR sg13_lv_pmos L=0.13u W=0.42u AS=0.2048p
+ AD=0.09345p PS=1.63u PD=0.865u
M$2003 \$I4789 \$I4780 VPWR VPWR sg13_lv_pmos L=0.13u W=0.42u AS=0.09345p
+ AD=0.204p PS=0.865u PD=1.835u
M$2004 VPWR \$24 \$I4780 VPWR sg13_lv_pmos L=0.13u W=0.42u AS=0.204p AD=0.0798p
+ PS=1.835u PD=0.8u
M$2005 \$I4780 \$I4783 VPWR VPWR sg13_lv_pmos L=0.13u W=0.42u AS=0.0798p
+ AD=0.4659p PS=0.8u PD=3.65u
M$2006 \$I4775 \$I4776 \$I4783 VPWR sg13_lv_pmos L=0.13u W=1u AS=0.34p
+ AD=0.2048p PS=2.68u PD=1.63u
M$2007 \$I4781 \$I4783 VPWR VPWR sg13_lv_pmos L=0.13u W=1.12u AS=0.3864p
+ AD=0.2128p PS=2.93u PD=1.5u
M$2008 VPWR \$I4781 \$19 VPWR sg13_lv_pmos L=0.13u W=1.12u AS=0.2128p
+ AD=0.3808p PS=1.5u PD=2.92u
M$2009 \$I4794 \$I4795 VGND VGND sg13_lv_nmos L=0.13u W=0.42u AS=0.1428p
+ AD=0.0798p PS=1.52u PD=0.8u
M$2010 VGND \$22 \$I4801 VGND sg13_lv_nmos L=0.13u W=0.42u AS=0.0798p
+ AD=0.0378p PS=0.8u PD=0.6u
M$2011 \$I4801 \$I4798 \$I4795 VGND sg13_lv_nmos L=0.13u W=0.42u AS=0.0378p
+ AD=0.1428p PS=0.6u PD=1.52u
M$2012 \$I4792 \$70 \$I4799 VGND sg13_lv_nmos L=0.13u W=0.42u AS=0.1428p
+ AD=0.0609p PS=1.52u PD=0.71u
M$2013 \$I4799 \$22 VGND VGND sg13_lv_nmos L=0.13u W=0.42u AS=0.0609p
+ AD=0.1626p PS=0.71u PD=1.415u
M$2014 VGND \$I4797 \$I4790 VGND sg13_lv_nmos L=0.13u W=0.74u AS=0.1626p
+ AD=0.2516p PS=1.415u PD=2.16u
M$2015 \$I4792 \$I4791 \$I4797 VGND sg13_lv_nmos L=0.13u W=0.42u AS=0.1296p
+ AD=0.0798p PS=1.52u PD=0.8u
M$2016 \$I4797 \$I4802 \$I4793 VGND sg13_lv_nmos L=0.13u W=0.42u AS=0.0798p
+ AD=0.2373p PS=0.8u PD=1.97u
M$2017 \$I4796 \$I4798 VGND VGND sg13_lv_nmos L=0.13u W=0.74u AS=0.2516p
+ AD=0.1406p PS=2.16u PD=1.12u
M$2018 VGND \$I4796 \$34 VGND sg13_lv_nmos L=0.13u W=0.74u AS=0.1406p
+ AD=0.2516p PS=1.12u PD=2.16u
M$2019 \$I4798 \$I4791 \$I4794 VGND sg13_lv_nmos L=0.13u W=0.42u AS=0.12665p
+ AD=0.1428p PS=1.145u PD=1.52u
M$2020 \$I4790 \$I4802 \$I4798 VGND sg13_lv_nmos L=0.13u W=0.74u AS=0.3473p
+ AD=0.12665p PS=2.71u PD=1.145u
M$2021 VGND \$22 \$I4800 VGND sg13_lv_nmos L=0.13u W=0.42u AS=0.1701p
+ AD=0.0378p PS=1.65u PD=0.6u
M$2022 \$I4800 \$I4790 \$I4793 VGND sg13_lv_nmos L=0.13u W=0.42u AS=0.0378p
+ AD=0.1428p PS=0.6u PD=1.52u
M$2023 VGND \$I4791 \$I4802 VGND sg13_lv_nmos L=0.13u W=0.74u AS=0.317325p
+ AD=0.2516p PS=1.805u PD=2.16u
M$2024 VGND \$15 \$I4791 VGND sg13_lv_nmos L=0.13u W=0.74u AS=0.317325p
+ AD=0.2516p PS=1.805u PD=2.16u
M$2025 \$I4797 \$22 VPWR VPWR sg13_lv_pmos L=0.13u W=0.42u AS=0.147p AD=0.1563p
+ PS=1.54u PD=1.22u
M$2026 VPWR \$I4790 \$I4803 VPWR sg13_lv_pmos L=0.13u W=0.42u AS=0.1563p
+ AD=0.063p PS=1.22u PD=0.72u
M$2027 \$I4803 \$I4791 \$I4797 VPWR sg13_lv_pmos L=0.13u W=0.42u AS=0.063p
+ AD=0.0798p PS=0.72u PD=0.8u
M$2028 \$I4797 \$I4802 \$I4792 VPWR sg13_lv_pmos L=0.13u W=0.42u AS=0.0798p
+ AD=0.1428p PS=0.8u PD=1.52u
M$2029 \$I4802 \$I4791 VPWR VPWR sg13_lv_pmos L=0.13u W=1.12u AS=0.3864p
+ AD=0.41165p PS=2.93u PD=2.12u
M$2030 VPWR \$15 \$I4791 VPWR sg13_lv_pmos L=0.13u W=1.12u AS=0.41165p
+ AD=0.4088p PS=2.12u PD=2.97u
M$2031 VPWR \$70 \$I4792 VPWR sg13_lv_pmos L=0.13u W=0.42u AS=0.1428p
+ AD=0.0798p PS=1.52u PD=0.8u
M$2032 VPWR \$22 \$I4792 VPWR sg13_lv_pmos L=0.13u W=0.42u AS=0.3623875p
+ AD=0.0798p PS=2.605u PD=0.8u
M$2033 VPWR \$I4797 \$I4790 VPWR sg13_lv_pmos L=0.13u W=1u AS=0.3623875p
+ AD=0.34p PS=2.605u PD=2.68u
M$2034 \$I4798 \$I4802 \$I4804 VPWR sg13_lv_pmos L=0.13u W=0.42u AS=0.2048p
+ AD=0.09345p PS=1.63u PD=0.865u
M$2035 \$I4804 \$I4795 VPWR VPWR sg13_lv_pmos L=0.13u W=0.42u AS=0.09345p
+ AD=0.204p PS=0.865u PD=1.835u
M$2036 VPWR \$22 \$I4795 VPWR sg13_lv_pmos L=0.13u W=0.42u AS=0.204p AD=0.0798p
+ PS=1.835u PD=0.8u
M$2037 \$I4795 \$I4798 VPWR VPWR sg13_lv_pmos L=0.13u W=0.42u AS=0.0798p
+ AD=0.4659p PS=0.8u PD=3.65u
M$2038 \$I4790 \$I4791 \$I4798 VPWR sg13_lv_pmos L=0.13u W=1u AS=0.34p
+ AD=0.2048p PS=2.68u PD=1.63u
M$2039 \$I4796 \$I4798 VPWR VPWR sg13_lv_pmos L=0.13u W=1.12u AS=0.3864p
+ AD=0.2128p PS=2.93u PD=1.5u
M$2040 VPWR \$I4796 \$34 VPWR sg13_lv_pmos L=0.13u W=1.12u AS=0.2128p
+ AD=0.3808p PS=1.5u PD=2.92u
M$2041 \$I4809 \$I4810 VGND VGND sg13_lv_nmos L=0.13u W=0.42u AS=0.1428p
+ AD=0.0798p PS=1.52u PD=0.8u
M$2042 VGND \$146 \$I4816 VGND sg13_lv_nmos L=0.13u W=0.42u AS=0.0798p
+ AD=0.0378p PS=0.8u PD=0.6u
M$2043 \$I4816 \$I4813 \$I4810 VGND sg13_lv_nmos L=0.13u W=0.42u AS=0.0378p
+ AD=0.1428p PS=0.6u PD=1.52u
M$2044 \$I4807 \$150 \$I4814 VGND sg13_lv_nmos L=0.13u W=0.42u AS=0.1428p
+ AD=0.0609p PS=1.52u PD=0.71u
M$2045 \$I4814 \$146 VGND VGND sg13_lv_nmos L=0.13u W=0.42u AS=0.0609p
+ AD=0.1626p PS=0.71u PD=1.415u
M$2046 VGND \$I4812 \$I4805 VGND sg13_lv_nmos L=0.13u W=0.74u AS=0.1626p
+ AD=0.2516p PS=1.415u PD=2.16u
M$2047 \$I4807 \$I4806 \$I4812 VGND sg13_lv_nmos L=0.13u W=0.42u AS=0.1296p
+ AD=0.0798p PS=1.52u PD=0.8u
M$2048 \$I4812 \$I4817 \$I4808 VGND sg13_lv_nmos L=0.13u W=0.42u AS=0.0798p
+ AD=0.2373p PS=0.8u PD=1.97u
M$2049 \$I4811 \$I4813 VGND VGND sg13_lv_nmos L=0.13u W=0.74u AS=0.2516p
+ AD=0.1406p PS=2.16u PD=1.12u
M$2050 VGND \$I4811 \$75 VGND sg13_lv_nmos L=0.13u W=0.74u AS=0.1406p
+ AD=0.2516p PS=1.12u PD=2.16u
M$2051 \$I4813 \$I4806 \$I4809 VGND sg13_lv_nmos L=0.13u W=0.42u AS=0.12665p
+ AD=0.1428p PS=1.145u PD=1.52u
M$2052 \$I4805 \$I4817 \$I4813 VGND sg13_lv_nmos L=0.13u W=0.74u AS=0.3473p
+ AD=0.12665p PS=2.71u PD=1.145u
M$2053 VGND \$146 \$I4815 VGND sg13_lv_nmos L=0.13u W=0.42u AS=0.1701p
+ AD=0.0378p PS=1.65u PD=0.6u
M$2054 \$I4815 \$I4805 \$I4808 VGND sg13_lv_nmos L=0.13u W=0.42u AS=0.0378p
+ AD=0.1428p PS=0.6u PD=1.52u
M$2055 VGND \$I4806 \$I4817 VGND sg13_lv_nmos L=0.13u W=0.74u AS=0.317325p
+ AD=0.2516p PS=1.805u PD=2.16u
M$2056 VGND \$15 \$I4806 VGND sg13_lv_nmos L=0.13u W=0.74u AS=0.317325p
+ AD=0.2516p PS=1.805u PD=2.16u
M$2057 \$I4812 \$146 VPWR VPWR sg13_lv_pmos L=0.13u W=0.42u AS=0.147p
+ AD=0.1563p PS=1.54u PD=1.22u
M$2058 VPWR \$I4805 \$I4818 VPWR sg13_lv_pmos L=0.13u W=0.42u AS=0.1563p
+ AD=0.063p PS=1.22u PD=0.72u
M$2059 \$I4818 \$I4806 \$I4812 VPWR sg13_lv_pmos L=0.13u W=0.42u AS=0.063p
+ AD=0.0798p PS=0.72u PD=0.8u
M$2060 \$I4812 \$I4817 \$I4807 VPWR sg13_lv_pmos L=0.13u W=0.42u AS=0.0798p
+ AD=0.1428p PS=0.8u PD=1.52u
M$2061 \$I4817 \$I4806 VPWR VPWR sg13_lv_pmos L=0.13u W=1.12u AS=0.3864p
+ AD=0.41165p PS=2.93u PD=2.12u
M$2062 VPWR \$15 \$I4806 VPWR sg13_lv_pmos L=0.13u W=1.12u AS=0.41165p
+ AD=0.4088p PS=2.12u PD=2.97u
M$2063 VPWR \$150 \$I4807 VPWR sg13_lv_pmos L=0.13u W=0.42u AS=0.1428p
+ AD=0.0798p PS=1.52u PD=0.8u
M$2064 VPWR \$146 \$I4807 VPWR sg13_lv_pmos L=0.13u W=0.42u AS=0.3623875p
+ AD=0.0798p PS=2.605u PD=0.8u
M$2065 VPWR \$I4812 \$I4805 VPWR sg13_lv_pmos L=0.13u W=1u AS=0.3623875p
+ AD=0.34p PS=2.605u PD=2.68u
M$2066 \$I4813 \$I4817 \$I4819 VPWR sg13_lv_pmos L=0.13u W=0.42u AS=0.2048p
+ AD=0.09345p PS=1.63u PD=0.865u
M$2067 \$I4819 \$I4810 VPWR VPWR sg13_lv_pmos L=0.13u W=0.42u AS=0.09345p
+ AD=0.204p PS=0.865u PD=1.835u
M$2068 VPWR \$146 \$I4810 VPWR sg13_lv_pmos L=0.13u W=0.42u AS=0.204p
+ AD=0.0798p PS=1.835u PD=0.8u
M$2069 \$I4810 \$I4813 VPWR VPWR sg13_lv_pmos L=0.13u W=0.42u AS=0.0798p
+ AD=0.4659p PS=0.8u PD=3.65u
M$2070 \$I4805 \$I4806 \$I4813 VPWR sg13_lv_pmos L=0.13u W=1u AS=0.34p
+ AD=0.2048p PS=2.68u PD=1.63u
M$2071 \$I4811 \$I4813 VPWR VPWR sg13_lv_pmos L=0.13u W=1.12u AS=0.3864p
+ AD=0.2128p PS=2.93u PD=1.5u
M$2072 VPWR \$I4811 \$75 VPWR sg13_lv_pmos L=0.13u W=1.12u AS=0.2128p
+ AD=0.3808p PS=1.5u PD=2.92u
M$2073 \$I4824 \$I4825 VGND VGND sg13_lv_nmos L=0.13u W=0.42u AS=0.1428p
+ AD=0.0798p PS=1.52u PD=0.8u
M$2074 VGND \$138 \$I4831 VGND sg13_lv_nmos L=0.13u W=0.42u AS=0.0798p
+ AD=0.0378p PS=0.8u PD=0.6u
M$2075 \$I4831 \$I4828 \$I4825 VGND sg13_lv_nmos L=0.13u W=0.42u AS=0.0378p
+ AD=0.1428p PS=0.6u PD=1.52u
M$2076 \$I4822 \$181 \$I4829 VGND sg13_lv_nmos L=0.13u W=0.42u AS=0.1428p
+ AD=0.0609p PS=1.52u PD=0.71u
M$2077 \$I4829 \$138 VGND VGND sg13_lv_nmos L=0.13u W=0.42u AS=0.0609p
+ AD=0.1626p PS=0.71u PD=1.415u
M$2078 VGND \$I4827 \$I4820 VGND sg13_lv_nmos L=0.13u W=0.74u AS=0.1626p
+ AD=0.2516p PS=1.415u PD=2.16u
M$2079 \$I4822 \$I4821 \$I4827 VGND sg13_lv_nmos L=0.13u W=0.42u AS=0.1296p
+ AD=0.0798p PS=1.52u PD=0.8u
M$2080 \$I4827 \$I4832 \$I4823 VGND sg13_lv_nmos L=0.13u W=0.42u AS=0.0798p
+ AD=0.2373p PS=0.8u PD=1.97u
M$2081 \$I4826 \$I4828 VGND VGND sg13_lv_nmos L=0.13u W=0.74u AS=0.2516p
+ AD=0.1406p PS=2.16u PD=1.12u
M$2082 VGND \$I4826 \$87 VGND sg13_lv_nmos L=0.13u W=0.74u AS=0.1406p
+ AD=0.2516p PS=1.12u PD=2.16u
M$2083 \$I4828 \$I4821 \$I4824 VGND sg13_lv_nmos L=0.13u W=0.42u AS=0.12665p
+ AD=0.1428p PS=1.145u PD=1.52u
M$2084 \$I4820 \$I4832 \$I4828 VGND sg13_lv_nmos L=0.13u W=0.74u AS=0.3473p
+ AD=0.12665p PS=2.71u PD=1.145u
M$2085 VGND \$138 \$I4830 VGND sg13_lv_nmos L=0.13u W=0.42u AS=0.1701p
+ AD=0.0378p PS=1.65u PD=0.6u
M$2086 \$I4830 \$I4820 \$I4823 VGND sg13_lv_nmos L=0.13u W=0.42u AS=0.0378p
+ AD=0.1428p PS=0.6u PD=1.52u
M$2087 VGND \$I4821 \$I4832 VGND sg13_lv_nmos L=0.13u W=0.74u AS=0.317325p
+ AD=0.2516p PS=1.805u PD=2.16u
M$2088 VGND \$52 \$I4821 VGND sg13_lv_nmos L=0.13u W=0.74u AS=0.317325p
+ AD=0.2516p PS=1.805u PD=2.16u
M$2089 \$I4827 \$138 VPWR VPWR sg13_lv_pmos L=0.13u W=0.42u AS=0.147p
+ AD=0.1563p PS=1.54u PD=1.22u
M$2090 VPWR \$I4820 \$I4833 VPWR sg13_lv_pmos L=0.13u W=0.42u AS=0.1563p
+ AD=0.063p PS=1.22u PD=0.72u
M$2091 \$I4833 \$I4821 \$I4827 VPWR sg13_lv_pmos L=0.13u W=0.42u AS=0.063p
+ AD=0.0798p PS=0.72u PD=0.8u
M$2092 \$I4827 \$I4832 \$I4822 VPWR sg13_lv_pmos L=0.13u W=0.42u AS=0.0798p
+ AD=0.1428p PS=0.8u PD=1.52u
M$2093 \$I4832 \$I4821 VPWR VPWR sg13_lv_pmos L=0.13u W=1.12u AS=0.3864p
+ AD=0.41165p PS=2.93u PD=2.12u
M$2094 VPWR \$52 \$I4821 VPWR sg13_lv_pmos L=0.13u W=1.12u AS=0.41165p
+ AD=0.4088p PS=2.12u PD=2.97u
M$2095 VPWR \$181 \$I4822 VPWR sg13_lv_pmos L=0.13u W=0.42u AS=0.1428p
+ AD=0.0798p PS=1.52u PD=0.8u
M$2096 VPWR \$138 \$I4822 VPWR sg13_lv_pmos L=0.13u W=0.42u AS=0.3623875p
+ AD=0.0798p PS=2.605u PD=0.8u
M$2097 VPWR \$I4827 \$I4820 VPWR sg13_lv_pmos L=0.13u W=1u AS=0.3623875p
+ AD=0.34p PS=2.605u PD=2.68u
M$2098 \$I4828 \$I4832 \$I4834 VPWR sg13_lv_pmos L=0.13u W=0.42u AS=0.2048p
+ AD=0.09345p PS=1.63u PD=0.865u
M$2099 \$I4834 \$I4825 VPWR VPWR sg13_lv_pmos L=0.13u W=0.42u AS=0.09345p
+ AD=0.204p PS=0.865u PD=1.835u
M$2100 VPWR \$138 \$I4825 VPWR sg13_lv_pmos L=0.13u W=0.42u AS=0.204p
+ AD=0.0798p PS=1.835u PD=0.8u
M$2101 \$I4825 \$I4828 VPWR VPWR sg13_lv_pmos L=0.13u W=0.42u AS=0.0798p
+ AD=0.4659p PS=0.8u PD=3.65u
M$2102 \$I4820 \$I4821 \$I4828 VPWR sg13_lv_pmos L=0.13u W=1u AS=0.34p
+ AD=0.2048p PS=2.68u PD=1.63u
M$2103 \$I4826 \$I4828 VPWR VPWR sg13_lv_pmos L=0.13u W=1.12u AS=0.3864p
+ AD=0.2128p PS=2.93u PD=1.5u
M$2104 VPWR \$I4826 \$87 VPWR sg13_lv_pmos L=0.13u W=1.12u AS=0.2128p
+ AD=0.3808p PS=1.5u PD=2.92u
M$2105 \$I4839 \$I4840 VGND VGND sg13_lv_nmos L=0.13u W=0.42u AS=0.1428p
+ AD=0.0798p PS=1.52u PD=0.8u
M$2106 VGND \$128 \$I4846 VGND sg13_lv_nmos L=0.13u W=0.42u AS=0.0798p
+ AD=0.0378p PS=0.8u PD=0.6u
M$2107 \$I4846 \$I4843 \$I4840 VGND sg13_lv_nmos L=0.13u W=0.42u AS=0.0378p
+ AD=0.1428p PS=0.6u PD=1.52u
M$2108 \$I4837 \$140 \$I4844 VGND sg13_lv_nmos L=0.13u W=0.42u AS=0.1428p
+ AD=0.0609p PS=1.52u PD=0.71u
M$2109 \$I4844 \$128 VGND VGND sg13_lv_nmos L=0.13u W=0.42u AS=0.0609p
+ AD=0.1626p PS=0.71u PD=1.415u
M$2110 VGND \$I4842 \$I4835 VGND sg13_lv_nmos L=0.13u W=0.74u AS=0.1626p
+ AD=0.2516p PS=1.415u PD=2.16u
M$2111 \$I4837 \$I4836 \$I4842 VGND sg13_lv_nmos L=0.13u W=0.42u AS=0.1296p
+ AD=0.0798p PS=1.52u PD=0.8u
M$2112 \$I4842 \$I4847 \$I4838 VGND sg13_lv_nmos L=0.13u W=0.42u AS=0.0798p
+ AD=0.2373p PS=0.8u PD=1.97u
M$2113 \$I4841 \$I4843 VGND VGND sg13_lv_nmos L=0.13u W=0.74u AS=0.2516p
+ AD=0.1406p PS=2.16u PD=1.12u
M$2114 VGND \$I4841 \$90 VGND sg13_lv_nmos L=0.13u W=0.74u AS=0.1406p
+ AD=0.2516p PS=1.12u PD=2.16u
M$2115 \$I4843 \$I4836 \$I4839 VGND sg13_lv_nmos L=0.13u W=0.42u AS=0.12665p
+ AD=0.1428p PS=1.145u PD=1.52u
M$2116 \$I4835 \$I4847 \$I4843 VGND sg13_lv_nmos L=0.13u W=0.74u AS=0.3473p
+ AD=0.12665p PS=2.71u PD=1.145u
M$2117 VGND \$128 \$I4845 VGND sg13_lv_nmos L=0.13u W=0.42u AS=0.1701p
+ AD=0.0378p PS=1.65u PD=0.6u
M$2118 \$I4845 \$I4835 \$I4838 VGND sg13_lv_nmos L=0.13u W=0.42u AS=0.0378p
+ AD=0.1428p PS=0.6u PD=1.52u
M$2119 VGND \$I4836 \$I4847 VGND sg13_lv_nmos L=0.13u W=0.74u AS=0.317325p
+ AD=0.2516p PS=1.805u PD=2.16u
M$2120 VGND \$52 \$I4836 VGND sg13_lv_nmos L=0.13u W=0.74u AS=0.317325p
+ AD=0.2516p PS=1.805u PD=2.16u
M$2121 \$I4842 \$128 VPWR VPWR sg13_lv_pmos L=0.13u W=0.42u AS=0.147p
+ AD=0.1563p PS=1.54u PD=1.22u
M$2122 VPWR \$I4835 \$I4848 VPWR sg13_lv_pmos L=0.13u W=0.42u AS=0.1563p
+ AD=0.063p PS=1.22u PD=0.72u
M$2123 \$I4848 \$I4836 \$I4842 VPWR sg13_lv_pmos L=0.13u W=0.42u AS=0.063p
+ AD=0.0798p PS=0.72u PD=0.8u
M$2124 \$I4842 \$I4847 \$I4837 VPWR sg13_lv_pmos L=0.13u W=0.42u AS=0.0798p
+ AD=0.1428p PS=0.8u PD=1.52u
M$2125 \$I4847 \$I4836 VPWR VPWR sg13_lv_pmos L=0.13u W=1.12u AS=0.3864p
+ AD=0.41165p PS=2.93u PD=2.12u
M$2126 VPWR \$52 \$I4836 VPWR sg13_lv_pmos L=0.13u W=1.12u AS=0.41165p
+ AD=0.4088p PS=2.12u PD=2.97u
M$2127 VPWR \$140 \$I4837 VPWR sg13_lv_pmos L=0.13u W=0.42u AS=0.1428p
+ AD=0.0798p PS=1.52u PD=0.8u
M$2128 VPWR \$128 \$I4837 VPWR sg13_lv_pmos L=0.13u W=0.42u AS=0.3623875p
+ AD=0.0798p PS=2.605u PD=0.8u
M$2129 VPWR \$I4842 \$I4835 VPWR sg13_lv_pmos L=0.13u W=1u AS=0.3623875p
+ AD=0.34p PS=2.605u PD=2.68u
M$2130 \$I4843 \$I4847 \$I4849 VPWR sg13_lv_pmos L=0.13u W=0.42u AS=0.2048p
+ AD=0.09345p PS=1.63u PD=0.865u
M$2131 \$I4849 \$I4840 VPWR VPWR sg13_lv_pmos L=0.13u W=0.42u AS=0.09345p
+ AD=0.204p PS=0.865u PD=1.835u
M$2132 VPWR \$128 \$I4840 VPWR sg13_lv_pmos L=0.13u W=0.42u AS=0.204p
+ AD=0.0798p PS=1.835u PD=0.8u
M$2133 \$I4840 \$I4843 VPWR VPWR sg13_lv_pmos L=0.13u W=0.42u AS=0.0798p
+ AD=0.4659p PS=0.8u PD=3.65u
M$2134 \$I4835 \$I4836 \$I4843 VPWR sg13_lv_pmos L=0.13u W=1u AS=0.34p
+ AD=0.2048p PS=2.68u PD=1.63u
M$2135 \$I4841 \$I4843 VPWR VPWR sg13_lv_pmos L=0.13u W=1.12u AS=0.3864p
+ AD=0.2128p PS=2.93u PD=1.5u
M$2136 VPWR \$I4841 \$90 VPWR sg13_lv_pmos L=0.13u W=1.12u AS=0.2128p
+ AD=0.3808p PS=1.5u PD=2.92u
M$2137 \$I4854 \$I4855 VGND VGND sg13_lv_nmos L=0.13u W=0.42u AS=0.1428p
+ AD=0.0798p PS=1.52u PD=0.8u
M$2138 VGND \$189 \$I4861 VGND sg13_lv_nmos L=0.13u W=0.42u AS=0.0798p
+ AD=0.0378p PS=0.8u PD=0.6u
M$2139 \$I4861 \$I4858 \$I4855 VGND sg13_lv_nmos L=0.13u W=0.42u AS=0.0378p
+ AD=0.1428p PS=0.6u PD=1.52u
M$2140 \$I4852 \$161 \$I4859 VGND sg13_lv_nmos L=0.13u W=0.42u AS=0.1428p
+ AD=0.0609p PS=1.52u PD=0.71u
M$2141 \$I4859 \$189 VGND VGND sg13_lv_nmos L=0.13u W=0.42u AS=0.0609p
+ AD=0.1626p PS=0.71u PD=1.415u
M$2142 VGND \$I4857 \$I4850 VGND sg13_lv_nmos L=0.13u W=0.74u AS=0.1626p
+ AD=0.2516p PS=1.415u PD=2.16u
M$2143 \$I4852 \$I4851 \$I4857 VGND sg13_lv_nmos L=0.13u W=0.42u AS=0.1296p
+ AD=0.0798p PS=1.52u PD=0.8u
M$2144 \$I4857 \$I4862 \$I4853 VGND sg13_lv_nmos L=0.13u W=0.42u AS=0.0798p
+ AD=0.2373p PS=0.8u PD=1.97u
M$2145 \$I4856 \$I4858 VGND VGND sg13_lv_nmos L=0.13u W=0.74u AS=0.2516p
+ AD=0.1406p PS=2.16u PD=1.12u
M$2146 VGND \$I4856 \$76 VGND sg13_lv_nmos L=0.13u W=0.74u AS=0.1406p
+ AD=0.2516p PS=1.12u PD=2.16u
M$2147 \$I4858 \$I4851 \$I4854 VGND sg13_lv_nmos L=0.13u W=0.42u AS=0.12665p
+ AD=0.1428p PS=1.145u PD=1.52u
M$2148 \$I4850 \$I4862 \$I4858 VGND sg13_lv_nmos L=0.13u W=0.74u AS=0.3473p
+ AD=0.12665p PS=2.71u PD=1.145u
M$2149 VGND \$189 \$I4860 VGND sg13_lv_nmos L=0.13u W=0.42u AS=0.1701p
+ AD=0.0378p PS=1.65u PD=0.6u
M$2150 \$I4860 \$I4850 \$I4853 VGND sg13_lv_nmos L=0.13u W=0.42u AS=0.0378p
+ AD=0.1428p PS=0.6u PD=1.52u
M$2151 VGND \$I4851 \$I4862 VGND sg13_lv_nmos L=0.13u W=0.74u AS=0.317325p
+ AD=0.2516p PS=1.805u PD=2.16u
M$2152 VGND \$15 \$I4851 VGND sg13_lv_nmos L=0.13u W=0.74u AS=0.317325p
+ AD=0.2516p PS=1.805u PD=2.16u
M$2153 \$I4857 \$189 VPWR VPWR sg13_lv_pmos L=0.13u W=0.42u AS=0.147p
+ AD=0.1563p PS=1.54u PD=1.22u
M$2154 VPWR \$I4850 \$I4863 VPWR sg13_lv_pmos L=0.13u W=0.42u AS=0.1563p
+ AD=0.063p PS=1.22u PD=0.72u
M$2155 \$I4863 \$I4851 \$I4857 VPWR sg13_lv_pmos L=0.13u W=0.42u AS=0.063p
+ AD=0.0798p PS=0.72u PD=0.8u
M$2156 \$I4857 \$I4862 \$I4852 VPWR sg13_lv_pmos L=0.13u W=0.42u AS=0.0798p
+ AD=0.1428p PS=0.8u PD=1.52u
M$2157 \$I4862 \$I4851 VPWR VPWR sg13_lv_pmos L=0.13u W=1.12u AS=0.3864p
+ AD=0.41165p PS=2.93u PD=2.12u
M$2158 VPWR \$15 \$I4851 VPWR sg13_lv_pmos L=0.13u W=1.12u AS=0.41165p
+ AD=0.4088p PS=2.12u PD=2.97u
M$2159 VPWR \$161 \$I4852 VPWR sg13_lv_pmos L=0.13u W=0.42u AS=0.1428p
+ AD=0.0798p PS=1.52u PD=0.8u
M$2160 VPWR \$189 \$I4852 VPWR sg13_lv_pmos L=0.13u W=0.42u AS=0.3623875p
+ AD=0.0798p PS=2.605u PD=0.8u
M$2161 VPWR \$I4857 \$I4850 VPWR sg13_lv_pmos L=0.13u W=1u AS=0.3623875p
+ AD=0.34p PS=2.605u PD=2.68u
M$2162 \$I4858 \$I4862 \$I4864 VPWR sg13_lv_pmos L=0.13u W=0.42u AS=0.2048p
+ AD=0.09345p PS=1.63u PD=0.865u
M$2163 \$I4864 \$I4855 VPWR VPWR sg13_lv_pmos L=0.13u W=0.42u AS=0.09345p
+ AD=0.204p PS=0.865u PD=1.835u
M$2164 VPWR \$189 \$I4855 VPWR sg13_lv_pmos L=0.13u W=0.42u AS=0.204p
+ AD=0.0798p PS=1.835u PD=0.8u
M$2165 \$I4855 \$I4858 VPWR VPWR sg13_lv_pmos L=0.13u W=0.42u AS=0.0798p
+ AD=0.4659p PS=0.8u PD=3.65u
M$2166 \$I4850 \$I4851 \$I4858 VPWR sg13_lv_pmos L=0.13u W=1u AS=0.34p
+ AD=0.2048p PS=2.68u PD=1.63u
M$2167 \$I4856 \$I4858 VPWR VPWR sg13_lv_pmos L=0.13u W=1.12u AS=0.3864p
+ AD=0.2128p PS=2.93u PD=1.5u
M$2168 VPWR \$I4856 \$76 VPWR sg13_lv_pmos L=0.13u W=1.12u AS=0.2128p
+ AD=0.3808p PS=1.5u PD=2.92u
M$2169 \$I4869 \$I4870 VGND VGND sg13_lv_nmos L=0.13u W=0.42u AS=0.1428p
+ AD=0.0798p PS=1.52u PD=0.8u
M$2170 VGND \$89 \$I4876 VGND sg13_lv_nmos L=0.13u W=0.42u AS=0.0798p
+ AD=0.0378p PS=0.8u PD=0.6u
M$2171 \$I4876 \$I4873 \$I4870 VGND sg13_lv_nmos L=0.13u W=0.42u AS=0.0378p
+ AD=0.1428p PS=0.6u PD=1.52u
M$2172 \$I4867 \$302 \$I4874 VGND sg13_lv_nmos L=0.13u W=0.42u AS=0.1428p
+ AD=0.0609p PS=1.52u PD=0.71u
M$2173 \$I4874 \$89 VGND VGND sg13_lv_nmos L=0.13u W=0.42u AS=0.0609p
+ AD=0.1626p PS=0.71u PD=1.415u
M$2174 VGND \$I4872 \$I4865 VGND sg13_lv_nmos L=0.13u W=0.74u AS=0.1626p
+ AD=0.2516p PS=1.415u PD=2.16u
M$2175 \$I4867 \$I4866 \$I4872 VGND sg13_lv_nmos L=0.13u W=0.42u AS=0.1296p
+ AD=0.0798p PS=1.52u PD=0.8u
M$2176 \$I4872 \$I4877 \$I4868 VGND sg13_lv_nmos L=0.13u W=0.42u AS=0.0798p
+ AD=0.2373p PS=0.8u PD=1.97u
M$2177 \$I4871 \$I4873 VGND VGND sg13_lv_nmos L=0.13u W=0.74u AS=0.2516p
+ AD=0.1406p PS=2.16u PD=1.12u
M$2178 VGND \$I4871 \$65 VGND sg13_lv_nmos L=0.13u W=0.74u AS=0.1406p
+ AD=0.2516p PS=1.12u PD=2.16u
M$2179 \$I4873 \$I4866 \$I4869 VGND sg13_lv_nmos L=0.13u W=0.42u AS=0.12665p
+ AD=0.1428p PS=1.145u PD=1.52u
M$2180 \$I4865 \$I4877 \$I4873 VGND sg13_lv_nmos L=0.13u W=0.74u AS=0.3473p
+ AD=0.12665p PS=2.71u PD=1.145u
M$2181 VGND \$89 \$I4875 VGND sg13_lv_nmos L=0.13u W=0.42u AS=0.1701p
+ AD=0.0378p PS=1.65u PD=0.6u
M$2182 \$I4875 \$I4865 \$I4868 VGND sg13_lv_nmos L=0.13u W=0.42u AS=0.0378p
+ AD=0.1428p PS=0.6u PD=1.52u
M$2183 VGND \$I4866 \$I4877 VGND sg13_lv_nmos L=0.13u W=0.74u AS=0.317325p
+ AD=0.2516p PS=1.805u PD=2.16u
M$2184 VGND \$52 \$I4866 VGND sg13_lv_nmos L=0.13u W=0.74u AS=0.317325p
+ AD=0.2516p PS=1.805u PD=2.16u
M$2185 \$I4872 \$89 VPWR VPWR sg13_lv_pmos L=0.13u W=0.42u AS=0.147p AD=0.1563p
+ PS=1.54u PD=1.22u
M$2186 VPWR \$I4865 \$I4878 VPWR sg13_lv_pmos L=0.13u W=0.42u AS=0.1563p
+ AD=0.063p PS=1.22u PD=0.72u
M$2187 \$I4878 \$I4866 \$I4872 VPWR sg13_lv_pmos L=0.13u W=0.42u AS=0.063p
+ AD=0.0798p PS=0.72u PD=0.8u
M$2188 \$I4872 \$I4877 \$I4867 VPWR sg13_lv_pmos L=0.13u W=0.42u AS=0.0798p
+ AD=0.1428p PS=0.8u PD=1.52u
M$2189 \$I4877 \$I4866 VPWR VPWR sg13_lv_pmos L=0.13u W=1.12u AS=0.3864p
+ AD=0.41165p PS=2.93u PD=2.12u
M$2190 VPWR \$52 \$I4866 VPWR sg13_lv_pmos L=0.13u W=1.12u AS=0.41165p
+ AD=0.4088p PS=2.12u PD=2.97u
M$2191 VPWR \$302 \$I4867 VPWR sg13_lv_pmos L=0.13u W=0.42u AS=0.1428p
+ AD=0.0798p PS=1.52u PD=0.8u
M$2192 VPWR \$89 \$I4867 VPWR sg13_lv_pmos L=0.13u W=0.42u AS=0.3623875p
+ AD=0.0798p PS=2.605u PD=0.8u
M$2193 VPWR \$I4872 \$I4865 VPWR sg13_lv_pmos L=0.13u W=1u AS=0.3623875p
+ AD=0.34p PS=2.605u PD=2.68u
M$2194 \$I4873 \$I4877 \$I4879 VPWR sg13_lv_pmos L=0.13u W=0.42u AS=0.2048p
+ AD=0.09345p PS=1.63u PD=0.865u
M$2195 \$I4879 \$I4870 VPWR VPWR sg13_lv_pmos L=0.13u W=0.42u AS=0.09345p
+ AD=0.204p PS=0.865u PD=1.835u
M$2196 VPWR \$89 \$I4870 VPWR sg13_lv_pmos L=0.13u W=0.42u AS=0.204p AD=0.0798p
+ PS=1.835u PD=0.8u
M$2197 \$I4870 \$I4873 VPWR VPWR sg13_lv_pmos L=0.13u W=0.42u AS=0.0798p
+ AD=0.4659p PS=0.8u PD=3.65u
M$2198 \$I4865 \$I4866 \$I4873 VPWR sg13_lv_pmos L=0.13u W=1u AS=0.34p
+ AD=0.2048p PS=2.68u PD=1.63u
M$2199 \$I4871 \$I4873 VPWR VPWR sg13_lv_pmos L=0.13u W=1.12u AS=0.3864p
+ AD=0.2128p PS=2.93u PD=1.5u
M$2200 VPWR \$I4871 \$65 VPWR sg13_lv_pmos L=0.13u W=1.12u AS=0.2128p
+ AD=0.3808p PS=1.5u PD=2.92u
M$2201 \$I4884 \$I4885 VGND VGND sg13_lv_nmos L=0.13u W=0.42u AS=0.1428p
+ AD=0.0798p PS=1.52u PD=0.8u
M$2202 VGND \$340 \$I4891 VGND sg13_lv_nmos L=0.13u W=0.42u AS=0.0798p
+ AD=0.0378p PS=0.8u PD=0.6u
M$2203 \$I4891 \$I4888 \$I4885 VGND sg13_lv_nmos L=0.13u W=0.42u AS=0.0378p
+ AD=0.1428p PS=0.6u PD=1.52u
M$2204 \$I4882 \$344 \$I4889 VGND sg13_lv_nmos L=0.13u W=0.42u AS=0.1428p
+ AD=0.0609p PS=1.52u PD=0.71u
M$2205 \$I4889 \$340 VGND VGND sg13_lv_nmos L=0.13u W=0.42u AS=0.0609p
+ AD=0.1626p PS=0.71u PD=1.415u
M$2206 VGND \$I4887 \$I4880 VGND sg13_lv_nmos L=0.13u W=0.74u AS=0.1626p
+ AD=0.2516p PS=1.415u PD=2.16u
M$2207 \$I4882 \$I4881 \$I4887 VGND sg13_lv_nmos L=0.13u W=0.42u AS=0.1296p
+ AD=0.0798p PS=1.52u PD=0.8u
M$2208 \$I4887 \$I4892 \$I4883 VGND sg13_lv_nmos L=0.13u W=0.42u AS=0.0798p
+ AD=0.2373p PS=0.8u PD=1.97u
M$2209 \$I4886 \$I4888 VGND VGND sg13_lv_nmos L=0.13u W=0.74u AS=0.2516p
+ AD=0.1406p PS=2.16u PD=1.12u
M$2210 VGND \$I4886 \$286 VGND sg13_lv_nmos L=0.13u W=0.74u AS=0.1406p
+ AD=0.2516p PS=1.12u PD=2.16u
M$2211 \$I4888 \$I4881 \$I4884 VGND sg13_lv_nmos L=0.13u W=0.42u AS=0.12665p
+ AD=0.1428p PS=1.145u PD=1.52u
M$2212 \$I4880 \$I4892 \$I4888 VGND sg13_lv_nmos L=0.13u W=0.74u AS=0.3473p
+ AD=0.12665p PS=2.71u PD=1.145u
M$2213 VGND \$340 \$I4890 VGND sg13_lv_nmos L=0.13u W=0.42u AS=0.1701p
+ AD=0.0378p PS=1.65u PD=0.6u
M$2214 \$I4890 \$I4880 \$I4883 VGND sg13_lv_nmos L=0.13u W=0.42u AS=0.0378p
+ AD=0.1428p PS=0.6u PD=1.52u
M$2215 VGND \$I4881 \$I4892 VGND sg13_lv_nmos L=0.13u W=0.74u AS=0.317325p
+ AD=0.2516p PS=1.805u PD=2.16u
M$2216 VGND \$15 \$I4881 VGND sg13_lv_nmos L=0.13u W=0.74u AS=0.317325p
+ AD=0.2516p PS=1.805u PD=2.16u
M$2217 \$I4887 \$340 VPWR VPWR sg13_lv_pmos L=0.13u W=0.42u AS=0.147p
+ AD=0.1563p PS=1.54u PD=1.22u
M$2218 VPWR \$I4880 \$I4893 VPWR sg13_lv_pmos L=0.13u W=0.42u AS=0.1563p
+ AD=0.063p PS=1.22u PD=0.72u
M$2219 \$I4893 \$I4881 \$I4887 VPWR sg13_lv_pmos L=0.13u W=0.42u AS=0.063p
+ AD=0.0798p PS=0.72u PD=0.8u
M$2220 \$I4887 \$I4892 \$I4882 VPWR sg13_lv_pmos L=0.13u W=0.42u AS=0.0798p
+ AD=0.1428p PS=0.8u PD=1.52u
M$2221 \$I4892 \$I4881 VPWR VPWR sg13_lv_pmos L=0.13u W=1.12u AS=0.3864p
+ AD=0.41165p PS=2.93u PD=2.12u
M$2222 VPWR \$15 \$I4881 VPWR sg13_lv_pmos L=0.13u W=1.12u AS=0.41165p
+ AD=0.4088p PS=2.12u PD=2.97u
M$2223 VPWR \$344 \$I4882 VPWR sg13_lv_pmos L=0.13u W=0.42u AS=0.1428p
+ AD=0.0798p PS=1.52u PD=0.8u
M$2224 VPWR \$340 \$I4882 VPWR sg13_lv_pmos L=0.13u W=0.42u AS=0.3623875p
+ AD=0.0798p PS=2.605u PD=0.8u
M$2225 VPWR \$I4887 \$I4880 VPWR sg13_lv_pmos L=0.13u W=1u AS=0.3623875p
+ AD=0.34p PS=2.605u PD=2.68u
M$2226 \$I4888 \$I4892 \$I4894 VPWR sg13_lv_pmos L=0.13u W=0.42u AS=0.2048p
+ AD=0.09345p PS=1.63u PD=0.865u
M$2227 \$I4894 \$I4885 VPWR VPWR sg13_lv_pmos L=0.13u W=0.42u AS=0.09345p
+ AD=0.204p PS=0.865u PD=1.835u
M$2228 VPWR \$340 \$I4885 VPWR sg13_lv_pmos L=0.13u W=0.42u AS=0.204p
+ AD=0.0798p PS=1.835u PD=0.8u
M$2229 \$I4885 \$I4888 VPWR VPWR sg13_lv_pmos L=0.13u W=0.42u AS=0.0798p
+ AD=0.4659p PS=0.8u PD=3.65u
M$2230 \$I4880 \$I4881 \$I4888 VPWR sg13_lv_pmos L=0.13u W=1u AS=0.34p
+ AD=0.2048p PS=2.68u PD=1.63u
M$2231 \$I4886 \$I4888 VPWR VPWR sg13_lv_pmos L=0.13u W=1.12u AS=0.3864p
+ AD=0.2128p PS=2.93u PD=1.5u
M$2232 VPWR \$I4886 \$286 VPWR sg13_lv_pmos L=0.13u W=1.12u AS=0.2128p
+ AD=0.3808p PS=1.5u PD=2.92u
M$2233 \$I4899 \$I4900 VGND VGND sg13_lv_nmos L=0.13u W=0.42u AS=0.1428p
+ AD=0.0798p PS=1.52u PD=0.8u
M$2234 VGND \$337 \$I4906 VGND sg13_lv_nmos L=0.13u W=0.42u AS=0.0798p
+ AD=0.0378p PS=0.8u PD=0.6u
M$2235 \$I4906 \$I4903 \$I4900 VGND sg13_lv_nmos L=0.13u W=0.42u AS=0.0378p
+ AD=0.1428p PS=0.6u PD=1.52u
M$2236 \$I4897 \$342 \$I4904 VGND sg13_lv_nmos L=0.13u W=0.42u AS=0.1428p
+ AD=0.0609p PS=1.52u PD=0.71u
M$2237 \$I4904 \$337 VGND VGND sg13_lv_nmos L=0.13u W=0.42u AS=0.0609p
+ AD=0.1626p PS=0.71u PD=1.415u
M$2238 VGND \$I4902 \$I4895 VGND sg13_lv_nmos L=0.13u W=0.74u AS=0.1626p
+ AD=0.2516p PS=1.415u PD=2.16u
M$2239 \$I4897 \$I4896 \$I4902 VGND sg13_lv_nmos L=0.13u W=0.42u AS=0.1296p
+ AD=0.0798p PS=1.52u PD=0.8u
M$2240 \$I4902 \$I4907 \$I4898 VGND sg13_lv_nmos L=0.13u W=0.42u AS=0.0798p
+ AD=0.2373p PS=0.8u PD=1.97u
M$2241 \$I4901 \$I4903 VGND VGND sg13_lv_nmos L=0.13u W=0.74u AS=0.2516p
+ AD=0.1406p PS=2.16u PD=1.12u
M$2242 VGND \$I4901 \$35 VGND sg13_lv_nmos L=0.13u W=0.74u AS=0.1406p
+ AD=0.2516p PS=1.12u PD=2.16u
M$2243 \$I4903 \$I4896 \$I4899 VGND sg13_lv_nmos L=0.13u W=0.42u AS=0.12665p
+ AD=0.1428p PS=1.145u PD=1.52u
M$2244 \$I4895 \$I4907 \$I4903 VGND sg13_lv_nmos L=0.13u W=0.74u AS=0.3473p
+ AD=0.12665p PS=2.71u PD=1.145u
M$2245 VGND \$337 \$I4905 VGND sg13_lv_nmos L=0.13u W=0.42u AS=0.1701p
+ AD=0.0378p PS=1.65u PD=0.6u
M$2246 \$I4905 \$I4895 \$I4898 VGND sg13_lv_nmos L=0.13u W=0.42u AS=0.0378p
+ AD=0.1428p PS=0.6u PD=1.52u
M$2247 VGND \$I4896 \$I4907 VGND sg13_lv_nmos L=0.13u W=0.74u AS=0.317325p
+ AD=0.2516p PS=1.805u PD=2.16u
M$2248 VGND \$52 \$I4896 VGND sg13_lv_nmos L=0.13u W=0.74u AS=0.317325p
+ AD=0.2516p PS=1.805u PD=2.16u
M$2249 \$I4902 \$337 VPWR VPWR sg13_lv_pmos L=0.13u W=0.42u AS=0.147p
+ AD=0.1563p PS=1.54u PD=1.22u
M$2250 VPWR \$I4895 \$I4908 VPWR sg13_lv_pmos L=0.13u W=0.42u AS=0.1563p
+ AD=0.063p PS=1.22u PD=0.72u
M$2251 \$I4908 \$I4896 \$I4902 VPWR sg13_lv_pmos L=0.13u W=0.42u AS=0.063p
+ AD=0.0798p PS=0.72u PD=0.8u
M$2252 \$I4902 \$I4907 \$I4897 VPWR sg13_lv_pmos L=0.13u W=0.42u AS=0.0798p
+ AD=0.1428p PS=0.8u PD=1.52u
M$2253 \$I4907 \$I4896 VPWR VPWR sg13_lv_pmos L=0.13u W=1.12u AS=0.3864p
+ AD=0.41165p PS=2.93u PD=2.12u
M$2254 VPWR \$52 \$I4896 VPWR sg13_lv_pmos L=0.13u W=1.12u AS=0.41165p
+ AD=0.4088p PS=2.12u PD=2.97u
M$2255 VPWR \$342 \$I4897 VPWR sg13_lv_pmos L=0.13u W=0.42u AS=0.1428p
+ AD=0.0798p PS=1.52u PD=0.8u
M$2256 VPWR \$337 \$I4897 VPWR sg13_lv_pmos L=0.13u W=0.42u AS=0.3623875p
+ AD=0.0798p PS=2.605u PD=0.8u
M$2257 VPWR \$I4902 \$I4895 VPWR sg13_lv_pmos L=0.13u W=1u AS=0.3623875p
+ AD=0.34p PS=2.605u PD=2.68u
M$2258 \$I4903 \$I4907 \$I4909 VPWR sg13_lv_pmos L=0.13u W=0.42u AS=0.2048p
+ AD=0.09345p PS=1.63u PD=0.865u
M$2259 \$I4909 \$I4900 VPWR VPWR sg13_lv_pmos L=0.13u W=0.42u AS=0.09345p
+ AD=0.204p PS=0.865u PD=1.835u
M$2260 VPWR \$337 \$I4900 VPWR sg13_lv_pmos L=0.13u W=0.42u AS=0.204p
+ AD=0.0798p PS=1.835u PD=0.8u
M$2261 \$I4900 \$I4903 VPWR VPWR sg13_lv_pmos L=0.13u W=0.42u AS=0.0798p
+ AD=0.4659p PS=0.8u PD=3.65u
M$2262 \$I4895 \$I4896 \$I4903 VPWR sg13_lv_pmos L=0.13u W=1u AS=0.34p
+ AD=0.2048p PS=2.68u PD=1.63u
M$2263 \$I4901 \$I4903 VPWR VPWR sg13_lv_pmos L=0.13u W=1.12u AS=0.3864p
+ AD=0.2128p PS=2.93u PD=1.5u
M$2264 VPWR \$I4901 \$35 VPWR sg13_lv_pmos L=0.13u W=1.12u AS=0.2128p
+ AD=0.3808p PS=1.5u PD=2.92u
M$2265 \$I4914 \$I4915 VGND VGND sg13_lv_nmos L=0.13u W=0.42u AS=0.1428p
+ AD=0.0798p PS=1.52u PD=0.8u
M$2266 VGND \$401 \$I4921 VGND sg13_lv_nmos L=0.13u W=0.42u AS=0.0798p
+ AD=0.0378p PS=0.8u PD=0.6u
M$2267 \$I4921 \$I4918 \$I4915 VGND sg13_lv_nmos L=0.13u W=0.42u AS=0.0378p
+ AD=0.1428p PS=0.6u PD=1.52u
M$2268 \$I4912 \$427 \$I4919 VGND sg13_lv_nmos L=0.13u W=0.42u AS=0.1428p
+ AD=0.0609p PS=1.52u PD=0.71u
M$2269 \$I4919 \$401 VGND VGND sg13_lv_nmos L=0.13u W=0.42u AS=0.0609p
+ AD=0.1626p PS=0.71u PD=1.415u
M$2270 VGND \$I4917 \$I4910 VGND sg13_lv_nmos L=0.13u W=0.74u AS=0.1626p
+ AD=0.2516p PS=1.415u PD=2.16u
M$2271 \$I4912 \$I4911 \$I4917 VGND sg13_lv_nmos L=0.13u W=0.42u AS=0.1296p
+ AD=0.0798p PS=1.52u PD=0.8u
M$2272 \$I4917 \$I4922 \$I4913 VGND sg13_lv_nmos L=0.13u W=0.42u AS=0.0798p
+ AD=0.2373p PS=0.8u PD=1.97u
M$2273 \$I4916 \$I4918 VGND VGND sg13_lv_nmos L=0.13u W=0.74u AS=0.2516p
+ AD=0.1406p PS=2.16u PD=1.12u
M$2274 VGND \$I4916 \$378 VGND sg13_lv_nmos L=0.13u W=0.74u AS=0.1406p
+ AD=0.2516p PS=1.12u PD=2.16u
M$2275 \$I4918 \$I4911 \$I4914 VGND sg13_lv_nmos L=0.13u W=0.42u AS=0.12665p
+ AD=0.1428p PS=1.145u PD=1.52u
M$2276 \$I4910 \$I4922 \$I4918 VGND sg13_lv_nmos L=0.13u W=0.74u AS=0.3473p
+ AD=0.12665p PS=2.71u PD=1.145u
M$2277 VGND \$401 \$I4920 VGND sg13_lv_nmos L=0.13u W=0.42u AS=0.1701p
+ AD=0.0378p PS=1.65u PD=0.6u
M$2278 \$I4920 \$I4910 \$I4913 VGND sg13_lv_nmos L=0.13u W=0.42u AS=0.0378p
+ AD=0.1428p PS=0.6u PD=1.52u
M$2279 VGND \$I4911 \$I4922 VGND sg13_lv_nmos L=0.13u W=0.74u AS=0.317325p
+ AD=0.2516p PS=1.805u PD=2.16u
M$2280 VGND \$15 \$I4911 VGND sg13_lv_nmos L=0.13u W=0.74u AS=0.317325p
+ AD=0.2516p PS=1.805u PD=2.16u
M$2281 \$I4917 \$401 VPWR VPWR sg13_lv_pmos L=0.13u W=0.42u AS=0.147p
+ AD=0.1563p PS=1.54u PD=1.22u
M$2282 VPWR \$I4910 \$I4923 VPWR sg13_lv_pmos L=0.13u W=0.42u AS=0.1563p
+ AD=0.063p PS=1.22u PD=0.72u
M$2283 \$I4923 \$I4911 \$I4917 VPWR sg13_lv_pmos L=0.13u W=0.42u AS=0.063p
+ AD=0.0798p PS=0.72u PD=0.8u
M$2284 \$I4917 \$I4922 \$I4912 VPWR sg13_lv_pmos L=0.13u W=0.42u AS=0.0798p
+ AD=0.1428p PS=0.8u PD=1.52u
M$2285 \$I4922 \$I4911 VPWR VPWR sg13_lv_pmos L=0.13u W=1.12u AS=0.3864p
+ AD=0.41165p PS=2.93u PD=2.12u
M$2286 VPWR \$15 \$I4911 VPWR sg13_lv_pmos L=0.13u W=1.12u AS=0.41165p
+ AD=0.4088p PS=2.12u PD=2.97u
M$2287 VPWR \$427 \$I4912 VPWR sg13_lv_pmos L=0.13u W=0.42u AS=0.1428p
+ AD=0.0798p PS=1.52u PD=0.8u
M$2288 VPWR \$401 \$I4912 VPWR sg13_lv_pmos L=0.13u W=0.42u AS=0.3623875p
+ AD=0.0798p PS=2.605u PD=0.8u
M$2289 VPWR \$I4917 \$I4910 VPWR sg13_lv_pmos L=0.13u W=1u AS=0.3623875p
+ AD=0.34p PS=2.605u PD=2.68u
M$2290 \$I4918 \$I4922 \$I4924 VPWR sg13_lv_pmos L=0.13u W=0.42u AS=0.2048p
+ AD=0.09345p PS=1.63u PD=0.865u
M$2291 \$I4924 \$I4915 VPWR VPWR sg13_lv_pmos L=0.13u W=0.42u AS=0.09345p
+ AD=0.204p PS=0.865u PD=1.835u
M$2292 VPWR \$401 \$I4915 VPWR sg13_lv_pmos L=0.13u W=0.42u AS=0.204p
+ AD=0.0798p PS=1.835u PD=0.8u
M$2293 \$I4915 \$I4918 VPWR VPWR sg13_lv_pmos L=0.13u W=0.42u AS=0.0798p
+ AD=0.4659p PS=0.8u PD=3.65u
M$2294 \$I4910 \$I4911 \$I4918 VPWR sg13_lv_pmos L=0.13u W=1u AS=0.34p
+ AD=0.2048p PS=2.68u PD=1.63u
M$2295 \$I4916 \$I4918 VPWR VPWR sg13_lv_pmos L=0.13u W=1.12u AS=0.3864p
+ AD=0.2128p PS=2.93u PD=1.5u
M$2296 VPWR \$I4916 \$378 VPWR sg13_lv_pmos L=0.13u W=1.12u AS=0.2128p
+ AD=0.3808p PS=1.5u PD=2.92u
M$2297 \$I4929 \$I4930 VGND VGND sg13_lv_nmos L=0.13u W=0.42u AS=0.1428p
+ AD=0.0798p PS=1.52u PD=0.8u
M$2298 VGND \$550 \$I4936 VGND sg13_lv_nmos L=0.13u W=0.42u AS=0.0798p
+ AD=0.0378p PS=0.8u PD=0.6u
M$2299 \$I4936 \$I4933 \$I4930 VGND sg13_lv_nmos L=0.13u W=0.42u AS=0.0378p
+ AD=0.1428p PS=0.6u PD=1.52u
M$2300 \$I4927 \$552 \$I4934 VGND sg13_lv_nmos L=0.13u W=0.42u AS=0.1428p
+ AD=0.0609p PS=1.52u PD=0.71u
M$2301 \$I4934 \$550 VGND VGND sg13_lv_nmos L=0.13u W=0.42u AS=0.0609p
+ AD=0.1626p PS=0.71u PD=1.415u
M$2302 VGND \$I4932 \$I4925 VGND sg13_lv_nmos L=0.13u W=0.74u AS=0.1626p
+ AD=0.2516p PS=1.415u PD=2.16u
M$2303 \$I4927 \$I4926 \$I4932 VGND sg13_lv_nmos L=0.13u W=0.42u AS=0.1296p
+ AD=0.0798p PS=1.52u PD=0.8u
M$2304 \$I4932 \$I4937 \$I4928 VGND sg13_lv_nmos L=0.13u W=0.42u AS=0.0798p
+ AD=0.2373p PS=0.8u PD=1.97u
M$2305 \$I4931 \$I4933 VGND VGND sg13_lv_nmos L=0.13u W=0.74u AS=0.2516p
+ AD=0.1406p PS=2.16u PD=1.12u
M$2306 VGND \$I4931 \$469 VGND sg13_lv_nmos L=0.13u W=0.74u AS=0.1406p
+ AD=0.2516p PS=1.12u PD=2.16u
M$2307 \$I4933 \$I4926 \$I4929 VGND sg13_lv_nmos L=0.13u W=0.42u AS=0.12665p
+ AD=0.1428p PS=1.145u PD=1.52u
M$2308 \$I4925 \$I4937 \$I4933 VGND sg13_lv_nmos L=0.13u W=0.74u AS=0.3473p
+ AD=0.12665p PS=2.71u PD=1.145u
M$2309 VGND \$550 \$I4935 VGND sg13_lv_nmos L=0.13u W=0.42u AS=0.1701p
+ AD=0.0378p PS=1.65u PD=0.6u
M$2310 \$I4935 \$I4925 \$I4928 VGND sg13_lv_nmos L=0.13u W=0.42u AS=0.0378p
+ AD=0.1428p PS=0.6u PD=1.52u
M$2311 VGND \$I4926 \$I4937 VGND sg13_lv_nmos L=0.13u W=0.74u AS=0.317325p
+ AD=0.2516p PS=1.805u PD=2.16u
M$2312 VGND \$15 \$I4926 VGND sg13_lv_nmos L=0.13u W=0.74u AS=0.317325p
+ AD=0.2516p PS=1.805u PD=2.16u
M$2313 \$I4932 \$550 VPWR VPWR sg13_lv_pmos L=0.13u W=0.42u AS=0.147p
+ AD=0.1563p PS=1.54u PD=1.22u
M$2314 VPWR \$I4925 \$I4938 VPWR sg13_lv_pmos L=0.13u W=0.42u AS=0.1563p
+ AD=0.063p PS=1.22u PD=0.72u
M$2315 \$I4938 \$I4926 \$I4932 VPWR sg13_lv_pmos L=0.13u W=0.42u AS=0.063p
+ AD=0.0798p PS=0.72u PD=0.8u
M$2316 \$I4932 \$I4937 \$I4927 VPWR sg13_lv_pmos L=0.13u W=0.42u AS=0.0798p
+ AD=0.1428p PS=0.8u PD=1.52u
M$2317 \$I4937 \$I4926 VPWR VPWR sg13_lv_pmos L=0.13u W=1.12u AS=0.3864p
+ AD=0.41165p PS=2.93u PD=2.12u
M$2318 VPWR \$15 \$I4926 VPWR sg13_lv_pmos L=0.13u W=1.12u AS=0.41165p
+ AD=0.4088p PS=2.12u PD=2.97u
M$2319 VPWR \$552 \$I4927 VPWR sg13_lv_pmos L=0.13u W=0.42u AS=0.1428p
+ AD=0.0798p PS=1.52u PD=0.8u
M$2320 VPWR \$550 \$I4927 VPWR sg13_lv_pmos L=0.13u W=0.42u AS=0.3623875p
+ AD=0.0798p PS=2.605u PD=0.8u
M$2321 VPWR \$I4932 \$I4925 VPWR sg13_lv_pmos L=0.13u W=1u AS=0.3623875p
+ AD=0.34p PS=2.605u PD=2.68u
M$2322 \$I4933 \$I4937 \$I4939 VPWR sg13_lv_pmos L=0.13u W=0.42u AS=0.2048p
+ AD=0.09345p PS=1.63u PD=0.865u
M$2323 \$I4939 \$I4930 VPWR VPWR sg13_lv_pmos L=0.13u W=0.42u AS=0.09345p
+ AD=0.204p PS=0.865u PD=1.835u
M$2324 VPWR \$550 \$I4930 VPWR sg13_lv_pmos L=0.13u W=0.42u AS=0.204p
+ AD=0.0798p PS=1.835u PD=0.8u
M$2325 \$I4930 \$I4933 VPWR VPWR sg13_lv_pmos L=0.13u W=0.42u AS=0.0798p
+ AD=0.4659p PS=0.8u PD=3.65u
M$2326 \$I4925 \$I4926 \$I4933 VPWR sg13_lv_pmos L=0.13u W=1u AS=0.34p
+ AD=0.2048p PS=2.68u PD=1.63u
M$2327 \$I4931 \$I4933 VPWR VPWR sg13_lv_pmos L=0.13u W=1.12u AS=0.3864p
+ AD=0.2128p PS=2.93u PD=1.5u
M$2328 VPWR \$I4931 \$469 VPWR sg13_lv_pmos L=0.13u W=1.12u AS=0.2128p
+ AD=0.3808p PS=1.5u PD=2.92u
M$2329 \$I4944 \$I4945 VGND VGND sg13_lv_nmos L=0.13u W=0.42u AS=0.1428p
+ AD=0.0798p PS=1.52u PD=0.8u
M$2330 VGND \$495 \$I4951 VGND sg13_lv_nmos L=0.13u W=0.42u AS=0.0798p
+ AD=0.0378p PS=0.8u PD=0.6u
M$2331 \$I4951 \$I4948 \$I4945 VGND sg13_lv_nmos L=0.13u W=0.42u AS=0.0378p
+ AD=0.1428p PS=0.6u PD=1.52u
M$2332 \$I4942 \$513 \$I4949 VGND sg13_lv_nmos L=0.13u W=0.42u AS=0.1428p
+ AD=0.0609p PS=1.52u PD=0.71u
M$2333 \$I4949 \$495 VGND VGND sg13_lv_nmos L=0.13u W=0.42u AS=0.0609p
+ AD=0.1626p PS=0.71u PD=1.415u
M$2334 VGND \$I4947 \$I4940 VGND sg13_lv_nmos L=0.13u W=0.74u AS=0.1626p
+ AD=0.2516p PS=1.415u PD=2.16u
M$2335 \$I4942 \$I4941 \$I4947 VGND sg13_lv_nmos L=0.13u W=0.42u AS=0.1296p
+ AD=0.0798p PS=1.52u PD=0.8u
M$2336 \$I4947 \$I4952 \$I4943 VGND sg13_lv_nmos L=0.13u W=0.42u AS=0.0798p
+ AD=0.2373p PS=0.8u PD=1.97u
M$2337 \$I4946 \$I4948 VGND VGND sg13_lv_nmos L=0.13u W=0.74u AS=0.2516p
+ AD=0.1406p PS=2.16u PD=1.12u
M$2338 VGND \$I4946 \$436 VGND sg13_lv_nmos L=0.13u W=0.74u AS=0.1406p
+ AD=0.2516p PS=1.12u PD=2.16u
M$2339 \$I4948 \$I4941 \$I4944 VGND sg13_lv_nmos L=0.13u W=0.42u AS=0.12665p
+ AD=0.1428p PS=1.145u PD=1.52u
M$2340 \$I4940 \$I4952 \$I4948 VGND sg13_lv_nmos L=0.13u W=0.74u AS=0.3473p
+ AD=0.12665p PS=2.71u PD=1.145u
M$2341 VGND \$495 \$I4950 VGND sg13_lv_nmos L=0.13u W=0.42u AS=0.1701p
+ AD=0.0378p PS=1.65u PD=0.6u
M$2342 \$I4950 \$I4940 \$I4943 VGND sg13_lv_nmos L=0.13u W=0.42u AS=0.0378p
+ AD=0.1428p PS=0.6u PD=1.52u
M$2343 VGND \$I4941 \$I4952 VGND sg13_lv_nmos L=0.13u W=0.74u AS=0.317325p
+ AD=0.2516p PS=1.805u PD=2.16u
M$2344 VGND \$608 \$I4941 VGND sg13_lv_nmos L=0.13u W=0.74u AS=0.317325p
+ AD=0.2516p PS=1.805u PD=2.16u
M$2345 \$I4947 \$495 VPWR VPWR sg13_lv_pmos L=0.13u W=0.42u AS=0.147p
+ AD=0.1563p PS=1.54u PD=1.22u
M$2346 VPWR \$I4940 \$I4953 VPWR sg13_lv_pmos L=0.13u W=0.42u AS=0.1563p
+ AD=0.063p PS=1.22u PD=0.72u
M$2347 \$I4953 \$I4941 \$I4947 VPWR sg13_lv_pmos L=0.13u W=0.42u AS=0.063p
+ AD=0.0798p PS=0.72u PD=0.8u
M$2348 \$I4947 \$I4952 \$I4942 VPWR sg13_lv_pmos L=0.13u W=0.42u AS=0.0798p
+ AD=0.1428p PS=0.8u PD=1.52u
M$2349 \$I4952 \$I4941 VPWR VPWR sg13_lv_pmos L=0.13u W=1.12u AS=0.3864p
+ AD=0.41165p PS=2.93u PD=2.12u
M$2350 VPWR \$608 \$I4941 VPWR sg13_lv_pmos L=0.13u W=1.12u AS=0.41165p
+ AD=0.4088p PS=2.12u PD=2.97u
M$2351 VPWR \$513 \$I4942 VPWR sg13_lv_pmos L=0.13u W=0.42u AS=0.1428p
+ AD=0.0798p PS=1.52u PD=0.8u
M$2352 VPWR \$495 \$I4942 VPWR sg13_lv_pmos L=0.13u W=0.42u AS=0.3623875p
+ AD=0.0798p PS=2.605u PD=0.8u
M$2353 VPWR \$I4947 \$I4940 VPWR sg13_lv_pmos L=0.13u W=1u AS=0.3623875p
+ AD=0.34p PS=2.605u PD=2.68u
M$2354 \$I4948 \$I4952 \$I4954 VPWR sg13_lv_pmos L=0.13u W=0.42u AS=0.2048p
+ AD=0.09345p PS=1.63u PD=0.865u
M$2355 \$I4954 \$I4945 VPWR VPWR sg13_lv_pmos L=0.13u W=0.42u AS=0.09345p
+ AD=0.204p PS=0.865u PD=1.835u
M$2356 VPWR \$495 \$I4945 VPWR sg13_lv_pmos L=0.13u W=0.42u AS=0.204p
+ AD=0.0798p PS=1.835u PD=0.8u
M$2357 \$I4945 \$I4948 VPWR VPWR sg13_lv_pmos L=0.13u W=0.42u AS=0.0798p
+ AD=0.4659p PS=0.8u PD=3.65u
M$2358 \$I4940 \$I4941 \$I4948 VPWR sg13_lv_pmos L=0.13u W=1u AS=0.34p
+ AD=0.2048p PS=2.68u PD=1.63u
M$2359 \$I4946 \$I4948 VPWR VPWR sg13_lv_pmos L=0.13u W=1.12u AS=0.3864p
+ AD=0.2128p PS=2.93u PD=1.5u
M$2360 VPWR \$I4946 \$436 VPWR sg13_lv_pmos L=0.13u W=1.12u AS=0.2128p
+ AD=0.3808p PS=1.5u PD=2.92u
M$2361 \$I4959 \$I4960 VGND VGND sg13_lv_nmos L=0.13u W=0.42u AS=0.1428p
+ AD=0.0798p PS=1.52u PD=0.8u
M$2362 VGND \$622 \$I4966 VGND sg13_lv_nmos L=0.13u W=0.42u AS=0.0798p
+ AD=0.0378p PS=0.8u PD=0.6u
M$2363 \$I4966 \$I4963 \$I4960 VGND sg13_lv_nmos L=0.13u W=0.42u AS=0.0378p
+ AD=0.1428p PS=0.6u PD=1.52u
M$2364 \$I4957 \$566 \$I4964 VGND sg13_lv_nmos L=0.13u W=0.42u AS=0.1428p
+ AD=0.0609p PS=1.52u PD=0.71u
M$2365 \$I4964 \$622 VGND VGND sg13_lv_nmos L=0.13u W=0.42u AS=0.0609p
+ AD=0.1626p PS=0.71u PD=1.415u
M$2366 VGND \$I4962 \$I4955 VGND sg13_lv_nmos L=0.13u W=0.74u AS=0.1626p
+ AD=0.2516p PS=1.415u PD=2.16u
M$2367 \$I4957 \$I4956 \$I4962 VGND sg13_lv_nmos L=0.13u W=0.42u AS=0.1296p
+ AD=0.0798p PS=1.52u PD=0.8u
M$2368 \$I4962 \$I4967 \$I4958 VGND sg13_lv_nmos L=0.13u W=0.42u AS=0.0798p
+ AD=0.2373p PS=0.8u PD=1.97u
M$2369 \$I4961 \$I4963 VGND VGND sg13_lv_nmos L=0.13u W=0.74u AS=0.2516p
+ AD=0.1406p PS=2.16u PD=1.12u
M$2370 VGND \$I4961 \$585 VGND sg13_lv_nmos L=0.13u W=0.74u AS=0.1406p
+ AD=0.2516p PS=1.12u PD=2.16u
M$2371 \$I4963 \$I4956 \$I4959 VGND sg13_lv_nmos L=0.13u W=0.42u AS=0.12665p
+ AD=0.1428p PS=1.145u PD=1.52u
M$2372 \$I4955 \$I4967 \$I4963 VGND sg13_lv_nmos L=0.13u W=0.74u AS=0.3473p
+ AD=0.12665p PS=2.71u PD=1.145u
M$2373 VGND \$622 \$I4965 VGND sg13_lv_nmos L=0.13u W=0.42u AS=0.1701p
+ AD=0.0378p PS=1.65u PD=0.6u
M$2374 \$I4965 \$I4955 \$I4958 VGND sg13_lv_nmos L=0.13u W=0.42u AS=0.0378p
+ AD=0.1428p PS=0.6u PD=1.52u
M$2375 VGND \$I4956 \$I4967 VGND sg13_lv_nmos L=0.13u W=0.74u AS=0.317325p
+ AD=0.2516p PS=1.805u PD=2.16u
M$2376 VGND \$587 \$I4956 VGND sg13_lv_nmos L=0.13u W=0.74u AS=0.317325p
+ AD=0.2516p PS=1.805u PD=2.16u
M$2377 \$I4962 \$622 VPWR VPWR sg13_lv_pmos L=0.13u W=0.42u AS=0.147p
+ AD=0.1563p PS=1.54u PD=1.22u
M$2378 VPWR \$I4955 \$I4968 VPWR sg13_lv_pmos L=0.13u W=0.42u AS=0.1563p
+ AD=0.063p PS=1.22u PD=0.72u
M$2379 \$I4968 \$I4956 \$I4962 VPWR sg13_lv_pmos L=0.13u W=0.42u AS=0.063p
+ AD=0.0798p PS=0.72u PD=0.8u
M$2380 \$I4962 \$I4967 \$I4957 VPWR sg13_lv_pmos L=0.13u W=0.42u AS=0.0798p
+ AD=0.1428p PS=0.8u PD=1.52u
M$2381 \$I4967 \$I4956 VPWR VPWR sg13_lv_pmos L=0.13u W=1.12u AS=0.3864p
+ AD=0.41165p PS=2.93u PD=2.12u
M$2382 VPWR \$587 \$I4956 VPWR sg13_lv_pmos L=0.13u W=1.12u AS=0.41165p
+ AD=0.4088p PS=2.12u PD=2.97u
M$2383 VPWR \$566 \$I4957 VPWR sg13_lv_pmos L=0.13u W=0.42u AS=0.1428p
+ AD=0.0798p PS=1.52u PD=0.8u
M$2384 VPWR \$622 \$I4957 VPWR sg13_lv_pmos L=0.13u W=0.42u AS=0.3623875p
+ AD=0.0798p PS=2.605u PD=0.8u
M$2385 VPWR \$I4962 \$I4955 VPWR sg13_lv_pmos L=0.13u W=1u AS=0.3623875p
+ AD=0.34p PS=2.605u PD=2.68u
M$2386 \$I4963 \$I4967 \$I4969 VPWR sg13_lv_pmos L=0.13u W=0.42u AS=0.2048p
+ AD=0.09345p PS=1.63u PD=0.865u
M$2387 \$I4969 \$I4960 VPWR VPWR sg13_lv_pmos L=0.13u W=0.42u AS=0.09345p
+ AD=0.204p PS=0.865u PD=1.835u
M$2388 VPWR \$622 \$I4960 VPWR sg13_lv_pmos L=0.13u W=0.42u AS=0.204p
+ AD=0.0798p PS=1.835u PD=0.8u
M$2389 \$I4960 \$I4963 VPWR VPWR sg13_lv_pmos L=0.13u W=0.42u AS=0.0798p
+ AD=0.4659p PS=0.8u PD=3.65u
M$2390 \$I4955 \$I4956 \$I4963 VPWR sg13_lv_pmos L=0.13u W=1u AS=0.34p
+ AD=0.2048p PS=2.68u PD=1.63u
M$2391 \$I4961 \$I4963 VPWR VPWR sg13_lv_pmos L=0.13u W=1.12u AS=0.3864p
+ AD=0.2128p PS=2.93u PD=1.5u
M$2392 VPWR \$I4961 \$585 VPWR sg13_lv_pmos L=0.13u W=1.12u AS=0.2128p
+ AD=0.3808p PS=1.5u PD=2.92u
M$2393 \$I4974 \$I4975 VGND VGND sg13_lv_nmos L=0.13u W=0.42u AS=0.1428p
+ AD=0.0798p PS=1.52u PD=0.8u
M$2394 VGND \$666 \$I4981 VGND sg13_lv_nmos L=0.13u W=0.42u AS=0.0798p
+ AD=0.0378p PS=0.8u PD=0.6u
M$2395 \$I4981 \$I4978 \$I4975 VGND sg13_lv_nmos L=0.13u W=0.42u AS=0.0378p
+ AD=0.1428p PS=0.6u PD=1.52u
M$2396 \$I4972 \$606 \$I4979 VGND sg13_lv_nmos L=0.13u W=0.42u AS=0.1428p
+ AD=0.0609p PS=1.52u PD=0.71u
M$2397 \$I4979 \$666 VGND VGND sg13_lv_nmos L=0.13u W=0.42u AS=0.0609p
+ AD=0.1626p PS=0.71u PD=1.415u
M$2398 VGND \$I4977 \$I4970 VGND sg13_lv_nmos L=0.13u W=0.74u AS=0.1626p
+ AD=0.2516p PS=1.415u PD=2.16u
M$2399 \$I4972 \$I4971 \$I4977 VGND sg13_lv_nmos L=0.13u W=0.42u AS=0.1296p
+ AD=0.0798p PS=1.52u PD=0.8u
M$2400 \$I4977 \$I4982 \$I4973 VGND sg13_lv_nmos L=0.13u W=0.42u AS=0.0798p
+ AD=0.2373p PS=0.8u PD=1.97u
M$2401 \$I4976 \$I4978 VGND VGND sg13_lv_nmos L=0.13u W=0.74u AS=0.2516p
+ AD=0.1406p PS=2.16u PD=1.12u
M$2402 VGND \$I4976 \$460 VGND sg13_lv_nmos L=0.13u W=0.74u AS=0.1406p
+ AD=0.2516p PS=1.12u PD=2.16u
M$2403 \$I4978 \$I4971 \$I4974 VGND sg13_lv_nmos L=0.13u W=0.42u AS=0.12665p
+ AD=0.1428p PS=1.145u PD=1.52u
M$2404 \$I4970 \$I4982 \$I4978 VGND sg13_lv_nmos L=0.13u W=0.74u AS=0.3473p
+ AD=0.12665p PS=2.71u PD=1.145u
M$2405 VGND \$666 \$I4980 VGND sg13_lv_nmos L=0.13u W=0.42u AS=0.1701p
+ AD=0.0378p PS=1.65u PD=0.6u
M$2406 \$I4980 \$I4970 \$I4973 VGND sg13_lv_nmos L=0.13u W=0.42u AS=0.0378p
+ AD=0.1428p PS=0.6u PD=1.52u
M$2407 VGND \$I4971 \$I4982 VGND sg13_lv_nmos L=0.13u W=0.74u AS=0.317325p
+ AD=0.2516p PS=1.805u PD=2.16u
M$2408 VGND \$608 \$I4971 VGND sg13_lv_nmos L=0.13u W=0.74u AS=0.317325p
+ AD=0.2516p PS=1.805u PD=2.16u
M$2409 \$I4977 \$666 VPWR VPWR sg13_lv_pmos L=0.13u W=0.42u AS=0.147p
+ AD=0.1563p PS=1.54u PD=1.22u
M$2410 VPWR \$I4970 \$I4983 VPWR sg13_lv_pmos L=0.13u W=0.42u AS=0.1563p
+ AD=0.063p PS=1.22u PD=0.72u
M$2411 \$I4983 \$I4971 \$I4977 VPWR sg13_lv_pmos L=0.13u W=0.42u AS=0.063p
+ AD=0.0798p PS=0.72u PD=0.8u
M$2412 \$I4977 \$I4982 \$I4972 VPWR sg13_lv_pmos L=0.13u W=0.42u AS=0.0798p
+ AD=0.1428p PS=0.8u PD=1.52u
M$2413 \$I4982 \$I4971 VPWR VPWR sg13_lv_pmos L=0.13u W=1.12u AS=0.3864p
+ AD=0.41165p PS=2.93u PD=2.12u
M$2414 VPWR \$608 \$I4971 VPWR sg13_lv_pmos L=0.13u W=1.12u AS=0.41165p
+ AD=0.4088p PS=2.12u PD=2.97u
M$2415 VPWR \$606 \$I4972 VPWR sg13_lv_pmos L=0.13u W=0.42u AS=0.1428p
+ AD=0.0798p PS=1.52u PD=0.8u
M$2416 VPWR \$666 \$I4972 VPWR sg13_lv_pmos L=0.13u W=0.42u AS=0.3623875p
+ AD=0.0798p PS=2.605u PD=0.8u
M$2417 VPWR \$I4977 \$I4970 VPWR sg13_lv_pmos L=0.13u W=1u AS=0.3623875p
+ AD=0.34p PS=2.605u PD=2.68u
M$2418 \$I4978 \$I4982 \$I4984 VPWR sg13_lv_pmos L=0.13u W=0.42u AS=0.2048p
+ AD=0.09345p PS=1.63u PD=0.865u
M$2419 \$I4984 \$I4975 VPWR VPWR sg13_lv_pmos L=0.13u W=0.42u AS=0.09345p
+ AD=0.204p PS=0.865u PD=1.835u
M$2420 VPWR \$666 \$I4975 VPWR sg13_lv_pmos L=0.13u W=0.42u AS=0.204p
+ AD=0.0798p PS=1.835u PD=0.8u
M$2421 \$I4975 \$I4978 VPWR VPWR sg13_lv_pmos L=0.13u W=0.42u AS=0.0798p
+ AD=0.4659p PS=0.8u PD=3.65u
M$2422 \$I4970 \$I4971 \$I4978 VPWR sg13_lv_pmos L=0.13u W=1u AS=0.34p
+ AD=0.2048p PS=2.68u PD=1.63u
M$2423 \$I4976 \$I4978 VPWR VPWR sg13_lv_pmos L=0.13u W=1.12u AS=0.3864p
+ AD=0.2128p PS=2.93u PD=1.5u
M$2424 VPWR \$I4976 \$460 VPWR sg13_lv_pmos L=0.13u W=1.12u AS=0.2128p
+ AD=0.3808p PS=1.5u PD=2.92u
M$2425 \$I4989 \$I4990 VGND VGND sg13_lv_nmos L=0.13u W=0.42u AS=0.1428p
+ AD=0.0798p PS=1.52u PD=0.8u
M$2426 VGND \$845 \$I4996 VGND sg13_lv_nmos L=0.13u W=0.42u AS=0.0798p
+ AD=0.0378p PS=0.8u PD=0.6u
M$2427 \$I4996 \$I4993 \$I4990 VGND sg13_lv_nmos L=0.13u W=0.42u AS=0.0378p
+ AD=0.1428p PS=0.6u PD=1.52u
M$2428 \$I4987 \$725 \$I4994 VGND sg13_lv_nmos L=0.13u W=0.42u AS=0.1428p
+ AD=0.0609p PS=1.52u PD=0.71u
M$2429 \$I4994 \$845 VGND VGND sg13_lv_nmos L=0.13u W=0.42u AS=0.0609p
+ AD=0.1626p PS=0.71u PD=1.415u
M$2430 VGND \$I4992 \$I4985 VGND sg13_lv_nmos L=0.13u W=0.74u AS=0.1626p
+ AD=0.2516p PS=1.415u PD=2.16u
M$2431 \$I4987 \$I4986 \$I4992 VGND sg13_lv_nmos L=0.13u W=0.42u AS=0.1296p
+ AD=0.0798p PS=1.52u PD=0.8u
M$2432 \$I4992 \$I4997 \$I4988 VGND sg13_lv_nmos L=0.13u W=0.42u AS=0.0798p
+ AD=0.2373p PS=0.8u PD=1.97u
M$2433 \$I4991 \$I4993 VGND VGND sg13_lv_nmos L=0.13u W=0.74u AS=0.2516p
+ AD=0.1406p PS=2.16u PD=1.12u
M$2434 VGND \$I4991 \$655 VGND sg13_lv_nmos L=0.13u W=0.74u AS=0.1406p
+ AD=0.2516p PS=1.12u PD=2.16u
M$2435 \$I4993 \$I4986 \$I4989 VGND sg13_lv_nmos L=0.13u W=0.42u AS=0.12665p
+ AD=0.1428p PS=1.145u PD=1.52u
M$2436 \$I4985 \$I4997 \$I4993 VGND sg13_lv_nmos L=0.13u W=0.74u AS=0.3473p
+ AD=0.12665p PS=2.71u PD=1.145u
M$2437 VGND \$845 \$I4995 VGND sg13_lv_nmos L=0.13u W=0.42u AS=0.1701p
+ AD=0.0378p PS=1.65u PD=0.6u
M$2438 \$I4995 \$I4985 \$I4988 VGND sg13_lv_nmos L=0.13u W=0.42u AS=0.0378p
+ AD=0.1428p PS=0.6u PD=1.52u
M$2439 VGND \$I4986 \$I4997 VGND sg13_lv_nmos L=0.13u W=0.74u AS=0.317325p
+ AD=0.2516p PS=1.805u PD=2.16u
M$2440 VGND \$608 \$I4986 VGND sg13_lv_nmos L=0.13u W=0.74u AS=0.317325p
+ AD=0.2516p PS=1.805u PD=2.16u
M$2441 \$I4992 \$845 VPWR VPWR sg13_lv_pmos L=0.13u W=0.42u AS=0.147p
+ AD=0.1563p PS=1.54u PD=1.22u
M$2442 VPWR \$I4985 \$I4998 VPWR sg13_lv_pmos L=0.13u W=0.42u AS=0.1563p
+ AD=0.063p PS=1.22u PD=0.72u
M$2443 \$I4998 \$I4986 \$I4992 VPWR sg13_lv_pmos L=0.13u W=0.42u AS=0.063p
+ AD=0.0798p PS=0.72u PD=0.8u
M$2444 \$I4992 \$I4997 \$I4987 VPWR sg13_lv_pmos L=0.13u W=0.42u AS=0.0798p
+ AD=0.1428p PS=0.8u PD=1.52u
M$2445 \$I4997 \$I4986 VPWR VPWR sg13_lv_pmos L=0.13u W=1.12u AS=0.3864p
+ AD=0.41165p PS=2.93u PD=2.12u
M$2446 VPWR \$608 \$I4986 VPWR sg13_lv_pmos L=0.13u W=1.12u AS=0.41165p
+ AD=0.4088p PS=2.12u PD=2.97u
M$2447 VPWR \$725 \$I4987 VPWR sg13_lv_pmos L=0.13u W=0.42u AS=0.1428p
+ AD=0.0798p PS=1.52u PD=0.8u
M$2448 VPWR \$845 \$I4987 VPWR sg13_lv_pmos L=0.13u W=0.42u AS=0.3623875p
+ AD=0.0798p PS=2.605u PD=0.8u
M$2449 VPWR \$I4992 \$I4985 VPWR sg13_lv_pmos L=0.13u W=1u AS=0.3623875p
+ AD=0.34p PS=2.605u PD=2.68u
M$2450 \$I4993 \$I4997 \$I4999 VPWR sg13_lv_pmos L=0.13u W=0.42u AS=0.2048p
+ AD=0.09345p PS=1.63u PD=0.865u
M$2451 \$I4999 \$I4990 VPWR VPWR sg13_lv_pmos L=0.13u W=0.42u AS=0.09345p
+ AD=0.204p PS=0.865u PD=1.835u
M$2452 VPWR \$845 \$I4990 VPWR sg13_lv_pmos L=0.13u W=0.42u AS=0.204p
+ AD=0.0798p PS=1.835u PD=0.8u
M$2453 \$I4990 \$I4993 VPWR VPWR sg13_lv_pmos L=0.13u W=0.42u AS=0.0798p
+ AD=0.4659p PS=0.8u PD=3.65u
M$2454 \$I4985 \$I4986 \$I4993 VPWR sg13_lv_pmos L=0.13u W=1u AS=0.34p
+ AD=0.2048p PS=2.68u PD=1.63u
M$2455 \$I4991 \$I4993 VPWR VPWR sg13_lv_pmos L=0.13u W=1.12u AS=0.3864p
+ AD=0.2128p PS=2.93u PD=1.5u
M$2456 VPWR \$I4991 \$655 VPWR sg13_lv_pmos L=0.13u W=1.12u AS=0.2128p
+ AD=0.3808p PS=1.5u PD=2.92u
M$2457 \$I5004 \$I5005 VGND VGND sg13_lv_nmos L=0.13u W=0.42u AS=0.1428p
+ AD=0.0798p PS=1.52u PD=0.8u
M$2458 VGND \$801 \$I5011 VGND sg13_lv_nmos L=0.13u W=0.42u AS=0.0798p
+ AD=0.0378p PS=0.8u PD=0.6u
M$2459 \$I5011 \$I5008 \$I5005 VGND sg13_lv_nmos L=0.13u W=0.42u AS=0.0378p
+ AD=0.1428p PS=0.6u PD=1.52u
M$2460 \$I5002 \$805 \$I5009 VGND sg13_lv_nmos L=0.13u W=0.42u AS=0.1428p
+ AD=0.0609p PS=1.52u PD=0.71u
M$2461 \$I5009 \$801 VGND VGND sg13_lv_nmos L=0.13u W=0.42u AS=0.0609p
+ AD=0.1626p PS=0.71u PD=1.415u
M$2462 VGND \$I5007 \$I5000 VGND sg13_lv_nmos L=0.13u W=0.74u AS=0.1626p
+ AD=0.2516p PS=1.415u PD=2.16u
M$2463 \$I5002 \$I5001 \$I5007 VGND sg13_lv_nmos L=0.13u W=0.42u AS=0.1296p
+ AD=0.0798p PS=1.52u PD=0.8u
M$2464 \$I5007 \$I5012 \$I5003 VGND sg13_lv_nmos L=0.13u W=0.42u AS=0.0798p
+ AD=0.2373p PS=0.8u PD=1.97u
M$2465 \$I5006 \$I5008 VGND VGND sg13_lv_nmos L=0.13u W=0.74u AS=0.2516p
+ AD=0.1406p PS=2.16u PD=1.12u
M$2466 VGND \$I5006 \$741 VGND sg13_lv_nmos L=0.13u W=0.74u AS=0.1406p
+ AD=0.2516p PS=1.12u PD=2.16u
M$2467 \$I5008 \$I5001 \$I5004 VGND sg13_lv_nmos L=0.13u W=0.42u AS=0.12665p
+ AD=0.1428p PS=1.145u PD=1.52u
M$2468 \$I5000 \$I5012 \$I5008 VGND sg13_lv_nmos L=0.13u W=0.74u AS=0.3473p
+ AD=0.12665p PS=2.71u PD=1.145u
M$2469 VGND \$801 \$I5010 VGND sg13_lv_nmos L=0.13u W=0.42u AS=0.1701p
+ AD=0.0378p PS=1.65u PD=0.6u
M$2470 \$I5010 \$I5000 \$I5003 VGND sg13_lv_nmos L=0.13u W=0.42u AS=0.0378p
+ AD=0.1428p PS=0.6u PD=1.52u
M$2471 VGND \$I5001 \$I5012 VGND sg13_lv_nmos L=0.13u W=0.74u AS=0.317325p
+ AD=0.2516p PS=1.805u PD=2.16u
M$2472 VGND \$587 \$I5001 VGND sg13_lv_nmos L=0.13u W=0.74u AS=0.317325p
+ AD=0.2516p PS=1.805u PD=2.16u
M$2473 \$I5007 \$801 VPWR VPWR sg13_lv_pmos L=0.13u W=0.42u AS=0.147p
+ AD=0.1563p PS=1.54u PD=1.22u
M$2474 VPWR \$I5000 \$I5013 VPWR sg13_lv_pmos L=0.13u W=0.42u AS=0.1563p
+ AD=0.063p PS=1.22u PD=0.72u
M$2475 \$I5013 \$I5001 \$I5007 VPWR sg13_lv_pmos L=0.13u W=0.42u AS=0.063p
+ AD=0.0798p PS=0.72u PD=0.8u
M$2476 \$I5007 \$I5012 \$I5002 VPWR sg13_lv_pmos L=0.13u W=0.42u AS=0.0798p
+ AD=0.1428p PS=0.8u PD=1.52u
M$2477 \$I5012 \$I5001 VPWR VPWR sg13_lv_pmos L=0.13u W=1.12u AS=0.3864p
+ AD=0.41165p PS=2.93u PD=2.12u
M$2478 VPWR \$587 \$I5001 VPWR sg13_lv_pmos L=0.13u W=1.12u AS=0.41165p
+ AD=0.4088p PS=2.12u PD=2.97u
M$2479 VPWR \$805 \$I5002 VPWR sg13_lv_pmos L=0.13u W=0.42u AS=0.1428p
+ AD=0.0798p PS=1.52u PD=0.8u
M$2480 VPWR \$801 \$I5002 VPWR sg13_lv_pmos L=0.13u W=0.42u AS=0.3623875p
+ AD=0.0798p PS=2.605u PD=0.8u
M$2481 VPWR \$I5007 \$I5000 VPWR sg13_lv_pmos L=0.13u W=1u AS=0.3623875p
+ AD=0.34p PS=2.605u PD=2.68u
M$2482 \$I5008 \$I5012 \$I5014 VPWR sg13_lv_pmos L=0.13u W=0.42u AS=0.2048p
+ AD=0.09345p PS=1.63u PD=0.865u
M$2483 \$I5014 \$I5005 VPWR VPWR sg13_lv_pmos L=0.13u W=0.42u AS=0.09345p
+ AD=0.204p PS=0.865u PD=1.835u
M$2484 VPWR \$801 \$I5005 VPWR sg13_lv_pmos L=0.13u W=0.42u AS=0.204p
+ AD=0.0798p PS=1.835u PD=0.8u
M$2485 \$I5005 \$I5008 VPWR VPWR sg13_lv_pmos L=0.13u W=0.42u AS=0.0798p
+ AD=0.4659p PS=0.8u PD=3.65u
M$2486 \$I5000 \$I5001 \$I5008 VPWR sg13_lv_pmos L=0.13u W=1u AS=0.34p
+ AD=0.2048p PS=2.68u PD=1.63u
M$2487 \$I5006 \$I5008 VPWR VPWR sg13_lv_pmos L=0.13u W=1.12u AS=0.3864p
+ AD=0.2128p PS=2.93u PD=1.5u
M$2488 VPWR \$I5006 \$741 VPWR sg13_lv_pmos L=0.13u W=1.12u AS=0.2128p
+ AD=0.3808p PS=1.5u PD=2.92u
M$2489 \$I5019 \$I5020 VGND VGND sg13_lv_nmos L=0.13u W=0.42u AS=0.1428p
+ AD=0.0798p PS=1.52u PD=0.8u
M$2490 VGND \$797 \$I5026 VGND sg13_lv_nmos L=0.13u W=0.42u AS=0.0798p
+ AD=0.0378p PS=0.8u PD=0.6u
M$2491 \$I5026 \$I5023 \$I5020 VGND sg13_lv_nmos L=0.13u W=0.42u AS=0.0378p
+ AD=0.1428p PS=0.6u PD=1.52u
M$2492 \$I5017 \$749 \$I5024 VGND sg13_lv_nmos L=0.13u W=0.42u AS=0.1428p
+ AD=0.0609p PS=1.52u PD=0.71u
M$2493 \$I5024 \$797 VGND VGND sg13_lv_nmos L=0.13u W=0.42u AS=0.0609p
+ AD=0.1626p PS=0.71u PD=1.415u
M$2494 VGND \$I5022 \$I5015 VGND sg13_lv_nmos L=0.13u W=0.74u AS=0.1626p
+ AD=0.2516p PS=1.415u PD=2.16u
M$2495 \$I5017 \$I5016 \$I5022 VGND sg13_lv_nmos L=0.13u W=0.42u AS=0.1296p
+ AD=0.0798p PS=1.52u PD=0.8u
M$2496 \$I5022 \$I5027 \$I5018 VGND sg13_lv_nmos L=0.13u W=0.42u AS=0.0798p
+ AD=0.2373p PS=0.8u PD=1.97u
M$2497 \$I5021 \$I5023 VGND VGND sg13_lv_nmos L=0.13u W=0.74u AS=0.2516p
+ AD=0.1406p PS=2.16u PD=1.12u
M$2498 VGND \$I5021 \$808 VGND sg13_lv_nmos L=0.13u W=0.74u AS=0.1406p
+ AD=0.2516p PS=1.12u PD=2.16u
M$2499 \$I5023 \$I5016 \$I5019 VGND sg13_lv_nmos L=0.13u W=0.42u AS=0.12665p
+ AD=0.1428p PS=1.145u PD=1.52u
M$2500 \$I5015 \$I5027 \$I5023 VGND sg13_lv_nmos L=0.13u W=0.74u AS=0.3473p
+ AD=0.12665p PS=2.71u PD=1.145u
M$2501 VGND \$797 \$I5025 VGND sg13_lv_nmos L=0.13u W=0.42u AS=0.1701p
+ AD=0.0378p PS=1.65u PD=0.6u
M$2502 \$I5025 \$I5015 \$I5018 VGND sg13_lv_nmos L=0.13u W=0.42u AS=0.0378p
+ AD=0.1428p PS=0.6u PD=1.52u
M$2503 VGND \$I5016 \$I5027 VGND sg13_lv_nmos L=0.13u W=0.74u AS=0.317325p
+ AD=0.2516p PS=1.805u PD=2.16u
M$2504 VGND \$608 \$I5016 VGND sg13_lv_nmos L=0.13u W=0.74u AS=0.317325p
+ AD=0.2516p PS=1.805u PD=2.16u
M$2505 \$I5022 \$797 VPWR VPWR sg13_lv_pmos L=0.13u W=0.42u AS=0.147p
+ AD=0.1563p PS=1.54u PD=1.22u
M$2506 VPWR \$I5015 \$I5028 VPWR sg13_lv_pmos L=0.13u W=0.42u AS=0.1563p
+ AD=0.063p PS=1.22u PD=0.72u
M$2507 \$I5028 \$I5016 \$I5022 VPWR sg13_lv_pmos L=0.13u W=0.42u AS=0.063p
+ AD=0.0798p PS=0.72u PD=0.8u
M$2508 \$I5022 \$I5027 \$I5017 VPWR sg13_lv_pmos L=0.13u W=0.42u AS=0.0798p
+ AD=0.1428p PS=0.8u PD=1.52u
M$2509 \$I5027 \$I5016 VPWR VPWR sg13_lv_pmos L=0.13u W=1.12u AS=0.3864p
+ AD=0.41165p PS=2.93u PD=2.12u
M$2510 VPWR \$608 \$I5016 VPWR sg13_lv_pmos L=0.13u W=1.12u AS=0.41165p
+ AD=0.4088p PS=2.12u PD=2.97u
M$2511 VPWR \$749 \$I5017 VPWR sg13_lv_pmos L=0.13u W=0.42u AS=0.1428p
+ AD=0.0798p PS=1.52u PD=0.8u
M$2512 VPWR \$797 \$I5017 VPWR sg13_lv_pmos L=0.13u W=0.42u AS=0.3623875p
+ AD=0.0798p PS=2.605u PD=0.8u
M$2513 VPWR \$I5022 \$I5015 VPWR sg13_lv_pmos L=0.13u W=1u AS=0.3623875p
+ AD=0.34p PS=2.605u PD=2.68u
M$2514 \$I5023 \$I5027 \$I5029 VPWR sg13_lv_pmos L=0.13u W=0.42u AS=0.2048p
+ AD=0.09345p PS=1.63u PD=0.865u
M$2515 \$I5029 \$I5020 VPWR VPWR sg13_lv_pmos L=0.13u W=0.42u AS=0.09345p
+ AD=0.204p PS=0.865u PD=1.835u
M$2516 VPWR \$797 \$I5020 VPWR sg13_lv_pmos L=0.13u W=0.42u AS=0.204p
+ AD=0.0798p PS=1.835u PD=0.8u
M$2517 \$I5020 \$I5023 VPWR VPWR sg13_lv_pmos L=0.13u W=0.42u AS=0.0798p
+ AD=0.4659p PS=0.8u PD=3.65u
M$2518 \$I5015 \$I5016 \$I5023 VPWR sg13_lv_pmos L=0.13u W=1u AS=0.34p
+ AD=0.2048p PS=2.68u PD=1.63u
M$2519 \$I5021 \$I5023 VPWR VPWR sg13_lv_pmos L=0.13u W=1.12u AS=0.3864p
+ AD=0.2128p PS=2.93u PD=1.5u
M$2520 VPWR \$I5021 \$808 VPWR sg13_lv_pmos L=0.13u W=1.12u AS=0.2128p
+ AD=0.3808p PS=1.5u PD=2.92u
M$2521 \$I5034 \$I5035 VGND VGND sg13_lv_nmos L=0.13u W=0.42u AS=0.1428p
+ AD=0.0798p PS=1.52u PD=0.8u
M$2522 VGND \$786 \$I5041 VGND sg13_lv_nmos L=0.13u W=0.42u AS=0.0798p
+ AD=0.0378p PS=0.8u PD=0.6u
M$2523 \$I5041 \$I5038 \$I5035 VGND sg13_lv_nmos L=0.13u W=0.42u AS=0.0378p
+ AD=0.1428p PS=0.6u PD=1.52u
M$2524 \$I5032 \$753 \$I5039 VGND sg13_lv_nmos L=0.13u W=0.42u AS=0.1428p
+ AD=0.0609p PS=1.52u PD=0.71u
M$2525 \$I5039 \$786 VGND VGND sg13_lv_nmos L=0.13u W=0.42u AS=0.0609p
+ AD=0.1626p PS=0.71u PD=1.415u
M$2526 VGND \$I5037 \$I5030 VGND sg13_lv_nmos L=0.13u W=0.74u AS=0.1626p
+ AD=0.2516p PS=1.415u PD=2.16u
M$2527 \$I5032 \$I5031 \$I5037 VGND sg13_lv_nmos L=0.13u W=0.42u AS=0.1296p
+ AD=0.0798p PS=1.52u PD=0.8u
M$2528 \$I5037 \$I5042 \$I5033 VGND sg13_lv_nmos L=0.13u W=0.42u AS=0.0798p
+ AD=0.2373p PS=0.8u PD=1.97u
M$2529 \$I5036 \$I5038 VGND VGND sg13_lv_nmos L=0.13u W=0.74u AS=0.2516p
+ AD=0.1406p PS=2.16u PD=1.12u
M$2530 VGND \$I5036 \$247 VGND sg13_lv_nmos L=0.13u W=0.74u AS=0.1406p
+ AD=0.2516p PS=1.12u PD=2.16u
M$2531 \$I5038 \$I5031 \$I5034 VGND sg13_lv_nmos L=0.13u W=0.42u AS=0.12665p
+ AD=0.1428p PS=1.145u PD=1.52u
M$2532 \$I5030 \$I5042 \$I5038 VGND sg13_lv_nmos L=0.13u W=0.74u AS=0.3473p
+ AD=0.12665p PS=2.71u PD=1.145u
M$2533 VGND \$786 \$I5040 VGND sg13_lv_nmos L=0.13u W=0.42u AS=0.1701p
+ AD=0.0378p PS=1.65u PD=0.6u
M$2534 \$I5040 \$I5030 \$I5033 VGND sg13_lv_nmos L=0.13u W=0.42u AS=0.0378p
+ AD=0.1428p PS=0.6u PD=1.52u
M$2535 VGND \$I5031 \$I5042 VGND sg13_lv_nmos L=0.13u W=0.74u AS=0.317325p
+ AD=0.2516p PS=1.805u PD=2.16u
M$2536 VGND \$608 \$I5031 VGND sg13_lv_nmos L=0.13u W=0.74u AS=0.317325p
+ AD=0.2516p PS=1.805u PD=2.16u
M$2537 \$I5037 \$786 VPWR VPWR sg13_lv_pmos L=0.13u W=0.42u AS=0.147p
+ AD=0.1563p PS=1.54u PD=1.22u
M$2538 VPWR \$I5030 \$I5043 VPWR sg13_lv_pmos L=0.13u W=0.42u AS=0.1563p
+ AD=0.063p PS=1.22u PD=0.72u
M$2539 \$I5043 \$I5031 \$I5037 VPWR sg13_lv_pmos L=0.13u W=0.42u AS=0.063p
+ AD=0.0798p PS=0.72u PD=0.8u
M$2540 \$I5037 \$I5042 \$I5032 VPWR sg13_lv_pmos L=0.13u W=0.42u AS=0.0798p
+ AD=0.1428p PS=0.8u PD=1.52u
M$2541 \$I5042 \$I5031 VPWR VPWR sg13_lv_pmos L=0.13u W=1.12u AS=0.3864p
+ AD=0.41165p PS=2.93u PD=2.12u
M$2542 VPWR \$608 \$I5031 VPWR sg13_lv_pmos L=0.13u W=1.12u AS=0.41165p
+ AD=0.4088p PS=2.12u PD=2.97u
M$2543 VPWR \$753 \$I5032 VPWR sg13_lv_pmos L=0.13u W=0.42u AS=0.1428p
+ AD=0.0798p PS=1.52u PD=0.8u
M$2544 VPWR \$786 \$I5032 VPWR sg13_lv_pmos L=0.13u W=0.42u AS=0.3623875p
+ AD=0.0798p PS=2.605u PD=0.8u
M$2545 VPWR \$I5037 \$I5030 VPWR sg13_lv_pmos L=0.13u W=1u AS=0.3623875p
+ AD=0.34p PS=2.605u PD=2.68u
M$2546 \$I5038 \$I5042 \$I5044 VPWR sg13_lv_pmos L=0.13u W=0.42u AS=0.2048p
+ AD=0.09345p PS=1.63u PD=0.865u
M$2547 \$I5044 \$I5035 VPWR VPWR sg13_lv_pmos L=0.13u W=0.42u AS=0.09345p
+ AD=0.204p PS=0.865u PD=1.835u
M$2548 VPWR \$786 \$I5035 VPWR sg13_lv_pmos L=0.13u W=0.42u AS=0.204p
+ AD=0.0798p PS=1.835u PD=0.8u
M$2549 \$I5035 \$I5038 VPWR VPWR sg13_lv_pmos L=0.13u W=0.42u AS=0.0798p
+ AD=0.4659p PS=0.8u PD=3.65u
M$2550 \$I5030 \$I5031 \$I5038 VPWR sg13_lv_pmos L=0.13u W=1u AS=0.34p
+ AD=0.2048p PS=2.68u PD=1.63u
M$2551 \$I5036 \$I5038 VPWR VPWR sg13_lv_pmos L=0.13u W=1.12u AS=0.3864p
+ AD=0.2128p PS=2.93u PD=1.5u
M$2552 VPWR \$I5036 \$247 VPWR sg13_lv_pmos L=0.13u W=1.12u AS=0.2128p
+ AD=0.3808p PS=1.5u PD=2.92u
M$2553 \$I5049 \$I5050 VGND VGND sg13_lv_nmos L=0.13u W=0.42u AS=0.1428p
+ AD=0.0798p PS=1.52u PD=0.8u
M$2554 VGND \$832 \$I5056 VGND sg13_lv_nmos L=0.13u W=0.42u AS=0.0798p
+ AD=0.0378p PS=0.8u PD=0.6u
M$2555 \$I5056 \$I5053 \$I5050 VGND sg13_lv_nmos L=0.13u W=0.42u AS=0.0378p
+ AD=0.1428p PS=0.6u PD=1.52u
M$2556 \$I5047 \$795 \$I5054 VGND sg13_lv_nmos L=0.13u W=0.42u AS=0.1428p
+ AD=0.0609p PS=1.52u PD=0.71u
M$2557 \$I5054 \$832 VGND VGND sg13_lv_nmos L=0.13u W=0.42u AS=0.0609p
+ AD=0.1626p PS=0.71u PD=1.415u
M$2558 VGND \$I5052 \$I5045 VGND sg13_lv_nmos L=0.13u W=0.74u AS=0.1626p
+ AD=0.2516p PS=1.415u PD=2.16u
M$2559 \$I5047 \$I5046 \$I5052 VGND sg13_lv_nmos L=0.13u W=0.42u AS=0.1296p
+ AD=0.0798p PS=1.52u PD=0.8u
M$2560 \$I5052 \$I5057 \$I5048 VGND sg13_lv_nmos L=0.13u W=0.42u AS=0.0798p
+ AD=0.2373p PS=0.8u PD=1.97u
M$2561 \$I5051 \$I5053 VGND VGND sg13_lv_nmos L=0.13u W=0.74u AS=0.2516p
+ AD=0.1406p PS=2.16u PD=1.12u
M$2562 VGND \$I5051 \$641 VGND sg13_lv_nmos L=0.13u W=0.74u AS=0.1406p
+ AD=0.2516p PS=1.12u PD=2.16u
M$2563 \$I5053 \$I5046 \$I5049 VGND sg13_lv_nmos L=0.13u W=0.42u AS=0.12665p
+ AD=0.1428p PS=1.145u PD=1.52u
M$2564 \$I5045 \$I5057 \$I5053 VGND sg13_lv_nmos L=0.13u W=0.74u AS=0.3473p
+ AD=0.12665p PS=2.71u PD=1.145u
M$2565 VGND \$832 \$I5055 VGND sg13_lv_nmos L=0.13u W=0.42u AS=0.1701p
+ AD=0.0378p PS=1.65u PD=0.6u
M$2566 \$I5055 \$I5045 \$I5048 VGND sg13_lv_nmos L=0.13u W=0.42u AS=0.0378p
+ AD=0.1428p PS=0.6u PD=1.52u
M$2567 VGND \$I5046 \$I5057 VGND sg13_lv_nmos L=0.13u W=0.74u AS=0.317325p
+ AD=0.2516p PS=1.805u PD=2.16u
M$2568 VGND \$587 \$I5046 VGND sg13_lv_nmos L=0.13u W=0.74u AS=0.317325p
+ AD=0.2516p PS=1.805u PD=2.16u
M$2569 \$I5052 \$832 VPWR VPWR sg13_lv_pmos L=0.13u W=0.42u AS=0.147p
+ AD=0.1563p PS=1.54u PD=1.22u
M$2570 VPWR \$I5045 \$I5058 VPWR sg13_lv_pmos L=0.13u W=0.42u AS=0.1563p
+ AD=0.063p PS=1.22u PD=0.72u
M$2571 \$I5058 \$I5046 \$I5052 VPWR sg13_lv_pmos L=0.13u W=0.42u AS=0.063p
+ AD=0.0798p PS=0.72u PD=0.8u
M$2572 \$I5052 \$I5057 \$I5047 VPWR sg13_lv_pmos L=0.13u W=0.42u AS=0.0798p
+ AD=0.1428p PS=0.8u PD=1.52u
M$2573 \$I5057 \$I5046 VPWR VPWR sg13_lv_pmos L=0.13u W=1.12u AS=0.3864p
+ AD=0.41165p PS=2.93u PD=2.12u
M$2574 VPWR \$587 \$I5046 VPWR sg13_lv_pmos L=0.13u W=1.12u AS=0.41165p
+ AD=0.4088p PS=2.12u PD=2.97u
M$2575 VPWR \$795 \$I5047 VPWR sg13_lv_pmos L=0.13u W=0.42u AS=0.1428p
+ AD=0.0798p PS=1.52u PD=0.8u
M$2576 VPWR \$832 \$I5047 VPWR sg13_lv_pmos L=0.13u W=0.42u AS=0.3623875p
+ AD=0.0798p PS=2.605u PD=0.8u
M$2577 VPWR \$I5052 \$I5045 VPWR sg13_lv_pmos L=0.13u W=1u AS=0.3623875p
+ AD=0.34p PS=2.605u PD=2.68u
M$2578 \$I5053 \$I5057 \$I5059 VPWR sg13_lv_pmos L=0.13u W=0.42u AS=0.2048p
+ AD=0.09345p PS=1.63u PD=0.865u
M$2579 \$I5059 \$I5050 VPWR VPWR sg13_lv_pmos L=0.13u W=0.42u AS=0.09345p
+ AD=0.204p PS=0.865u PD=1.835u
M$2580 VPWR \$832 \$I5050 VPWR sg13_lv_pmos L=0.13u W=0.42u AS=0.204p
+ AD=0.0798p PS=1.835u PD=0.8u
M$2581 \$I5050 \$I5053 VPWR VPWR sg13_lv_pmos L=0.13u W=0.42u AS=0.0798p
+ AD=0.4659p PS=0.8u PD=3.65u
M$2582 \$I5045 \$I5046 \$I5053 VPWR sg13_lv_pmos L=0.13u W=1u AS=0.34p
+ AD=0.2048p PS=2.68u PD=1.63u
M$2583 \$I5051 \$I5053 VPWR VPWR sg13_lv_pmos L=0.13u W=1.12u AS=0.3864p
+ AD=0.2128p PS=2.93u PD=1.5u
M$2584 VPWR \$I5051 \$641 VPWR sg13_lv_pmos L=0.13u W=1.12u AS=0.2128p
+ AD=0.3808p PS=1.5u PD=2.92u
M$2585 \$I5064 \$I5065 VGND VGND sg13_lv_nmos L=0.13u W=0.42u AS=0.1428p
+ AD=0.0798p PS=1.52u PD=0.8u
M$2586 VGND \$816 \$I5071 VGND sg13_lv_nmos L=0.13u W=0.42u AS=0.0798p
+ AD=0.0378p PS=0.8u PD=0.6u
M$2587 \$I5071 \$I5068 \$I5065 VGND sg13_lv_nmos L=0.13u W=0.42u AS=0.0378p
+ AD=0.1428p PS=0.6u PD=1.52u
M$2588 \$I5062 \$745 \$I5069 VGND sg13_lv_nmos L=0.13u W=0.42u AS=0.1428p
+ AD=0.0609p PS=1.52u PD=0.71u
M$2589 \$I5069 \$816 VGND VGND sg13_lv_nmos L=0.13u W=0.42u AS=0.0609p
+ AD=0.1626p PS=0.71u PD=1.415u
M$2590 VGND \$I5067 \$I5060 VGND sg13_lv_nmos L=0.13u W=0.74u AS=0.1626p
+ AD=0.2516p PS=1.415u PD=2.16u
M$2591 \$I5062 \$I5061 \$I5067 VGND sg13_lv_nmos L=0.13u W=0.42u AS=0.1296p
+ AD=0.0798p PS=1.52u PD=0.8u
M$2592 \$I5067 \$I5072 \$I5063 VGND sg13_lv_nmos L=0.13u W=0.42u AS=0.0798p
+ AD=0.2373p PS=0.8u PD=1.97u
M$2593 \$I5066 \$I5068 VGND VGND sg13_lv_nmos L=0.13u W=0.74u AS=0.2516p
+ AD=0.1406p PS=2.16u PD=1.12u
M$2594 VGND \$I5066 \$817 VGND sg13_lv_nmos L=0.13u W=0.74u AS=0.1406p
+ AD=0.2516p PS=1.12u PD=2.16u
M$2595 \$I5068 \$I5061 \$I5064 VGND sg13_lv_nmos L=0.13u W=0.42u AS=0.12665p
+ AD=0.1428p PS=1.145u PD=1.52u
M$2596 \$I5060 \$I5072 \$I5068 VGND sg13_lv_nmos L=0.13u W=0.74u AS=0.3473p
+ AD=0.12665p PS=2.71u PD=1.145u
M$2597 VGND \$816 \$I5070 VGND sg13_lv_nmos L=0.13u W=0.42u AS=0.1701p
+ AD=0.0378p PS=1.65u PD=0.6u
M$2598 \$I5070 \$I5060 \$I5063 VGND sg13_lv_nmos L=0.13u W=0.42u AS=0.0378p
+ AD=0.1428p PS=0.6u PD=1.52u
M$2599 VGND \$I5061 \$I5072 VGND sg13_lv_nmos L=0.13u W=0.74u AS=0.317325p
+ AD=0.2516p PS=1.805u PD=2.16u
M$2600 VGND \$587 \$I5061 VGND sg13_lv_nmos L=0.13u W=0.74u AS=0.317325p
+ AD=0.2516p PS=1.805u PD=2.16u
M$2601 \$I5067 \$816 VPWR VPWR sg13_lv_pmos L=0.13u W=0.42u AS=0.147p
+ AD=0.1563p PS=1.54u PD=1.22u
M$2602 VPWR \$I5060 \$I5073 VPWR sg13_lv_pmos L=0.13u W=0.42u AS=0.1563p
+ AD=0.063p PS=1.22u PD=0.72u
M$2603 \$I5073 \$I5061 \$I5067 VPWR sg13_lv_pmos L=0.13u W=0.42u AS=0.063p
+ AD=0.0798p PS=0.72u PD=0.8u
M$2604 \$I5067 \$I5072 \$I5062 VPWR sg13_lv_pmos L=0.13u W=0.42u AS=0.0798p
+ AD=0.1428p PS=0.8u PD=1.52u
M$2605 \$I5072 \$I5061 VPWR VPWR sg13_lv_pmos L=0.13u W=1.12u AS=0.3864p
+ AD=0.41165p PS=2.93u PD=2.12u
M$2606 VPWR \$587 \$I5061 VPWR sg13_lv_pmos L=0.13u W=1.12u AS=0.41165p
+ AD=0.4088p PS=2.12u PD=2.97u
M$2607 VPWR \$745 \$I5062 VPWR sg13_lv_pmos L=0.13u W=0.42u AS=0.1428p
+ AD=0.0798p PS=1.52u PD=0.8u
M$2608 VPWR \$816 \$I5062 VPWR sg13_lv_pmos L=0.13u W=0.42u AS=0.3623875p
+ AD=0.0798p PS=2.605u PD=0.8u
M$2609 VPWR \$I5067 \$I5060 VPWR sg13_lv_pmos L=0.13u W=1u AS=0.3623875p
+ AD=0.34p PS=2.605u PD=2.68u
M$2610 \$I5068 \$I5072 \$I5074 VPWR sg13_lv_pmos L=0.13u W=0.42u AS=0.2048p
+ AD=0.09345p PS=1.63u PD=0.865u
M$2611 \$I5074 \$I5065 VPWR VPWR sg13_lv_pmos L=0.13u W=0.42u AS=0.09345p
+ AD=0.204p PS=0.865u PD=1.835u
M$2612 VPWR \$816 \$I5065 VPWR sg13_lv_pmos L=0.13u W=0.42u AS=0.204p
+ AD=0.0798p PS=1.835u PD=0.8u
M$2613 \$I5065 \$I5068 VPWR VPWR sg13_lv_pmos L=0.13u W=0.42u AS=0.0798p
+ AD=0.4659p PS=0.8u PD=3.65u
M$2614 \$I5060 \$I5061 \$I5068 VPWR sg13_lv_pmos L=0.13u W=1u AS=0.34p
+ AD=0.2048p PS=2.68u PD=1.63u
M$2615 \$I5066 \$I5068 VPWR VPWR sg13_lv_pmos L=0.13u W=1.12u AS=0.3864p
+ AD=0.2128p PS=2.93u PD=1.5u
M$2616 VPWR \$I5066 \$817 VPWR sg13_lv_pmos L=0.13u W=1.12u AS=0.2128p
+ AD=0.3808p PS=1.5u PD=2.92u
M$2617 \$I5079 \$I5080 VGND VGND sg13_lv_nmos L=0.13u W=0.42u AS=0.1428p
+ AD=0.0798p PS=1.52u PD=0.8u
M$2618 VGND \$823 \$I5086 VGND sg13_lv_nmos L=0.13u W=0.42u AS=0.0798p
+ AD=0.0378p PS=0.8u PD=0.6u
M$2619 \$I5086 \$I5083 \$I5080 VGND sg13_lv_nmos L=0.13u W=0.42u AS=0.0378p
+ AD=0.1428p PS=0.6u PD=1.52u
M$2620 \$I5077 \$822 \$I5084 VGND sg13_lv_nmos L=0.13u W=0.42u AS=0.1428p
+ AD=0.0609p PS=1.52u PD=0.71u
M$2621 \$I5084 \$823 VGND VGND sg13_lv_nmos L=0.13u W=0.42u AS=0.0609p
+ AD=0.1626p PS=0.71u PD=1.415u
M$2622 VGND \$I5082 \$I5075 VGND sg13_lv_nmos L=0.13u W=0.74u AS=0.1626p
+ AD=0.2516p PS=1.415u PD=2.16u
M$2623 \$I5077 \$I5076 \$I5082 VGND sg13_lv_nmos L=0.13u W=0.42u AS=0.1296p
+ AD=0.0798p PS=1.52u PD=0.8u
M$2624 \$I5082 \$I5087 \$I5078 VGND sg13_lv_nmos L=0.13u W=0.42u AS=0.0798p
+ AD=0.2373p PS=0.8u PD=1.97u
M$2625 \$I5081 \$I5083 VGND VGND sg13_lv_nmos L=0.13u W=0.74u AS=0.2516p
+ AD=0.1406p PS=2.16u PD=1.12u
M$2626 VGND \$I5081 \$825 VGND sg13_lv_nmos L=0.13u W=0.74u AS=0.1406p
+ AD=0.2516p PS=1.12u PD=2.16u
M$2627 \$I5083 \$I5076 \$I5079 VGND sg13_lv_nmos L=0.13u W=0.42u AS=0.12665p
+ AD=0.1428p PS=1.145u PD=1.52u
M$2628 \$I5075 \$I5087 \$I5083 VGND sg13_lv_nmos L=0.13u W=0.74u AS=0.3473p
+ AD=0.12665p PS=2.71u PD=1.145u
M$2629 VGND \$823 \$I5085 VGND sg13_lv_nmos L=0.13u W=0.42u AS=0.1701p
+ AD=0.0378p PS=1.65u PD=0.6u
M$2630 \$I5085 \$I5075 \$I5078 VGND sg13_lv_nmos L=0.13u W=0.42u AS=0.0378p
+ AD=0.1428p PS=0.6u PD=1.52u
M$2631 VGND \$I5076 \$I5087 VGND sg13_lv_nmos L=0.13u W=0.74u AS=0.317325p
+ AD=0.2516p PS=1.805u PD=2.16u
M$2632 VGND \$608 \$I5076 VGND sg13_lv_nmos L=0.13u W=0.74u AS=0.317325p
+ AD=0.2516p PS=1.805u PD=2.16u
M$2633 \$I5082 \$823 VPWR VPWR sg13_lv_pmos L=0.13u W=0.42u AS=0.147p
+ AD=0.1563p PS=1.54u PD=1.22u
M$2634 VPWR \$I5075 \$I5088 VPWR sg13_lv_pmos L=0.13u W=0.42u AS=0.1563p
+ AD=0.063p PS=1.22u PD=0.72u
M$2635 \$I5088 \$I5076 \$I5082 VPWR sg13_lv_pmos L=0.13u W=0.42u AS=0.063p
+ AD=0.0798p PS=0.72u PD=0.8u
M$2636 \$I5082 \$I5087 \$I5077 VPWR sg13_lv_pmos L=0.13u W=0.42u AS=0.0798p
+ AD=0.1428p PS=0.8u PD=1.52u
M$2637 \$I5087 \$I5076 VPWR VPWR sg13_lv_pmos L=0.13u W=1.12u AS=0.3864p
+ AD=0.41165p PS=2.93u PD=2.12u
M$2638 VPWR \$608 \$I5076 VPWR sg13_lv_pmos L=0.13u W=1.12u AS=0.41165p
+ AD=0.4088p PS=2.12u PD=2.97u
M$2639 VPWR \$822 \$I5077 VPWR sg13_lv_pmos L=0.13u W=0.42u AS=0.1428p
+ AD=0.0798p PS=1.52u PD=0.8u
M$2640 VPWR \$823 \$I5077 VPWR sg13_lv_pmos L=0.13u W=0.42u AS=0.3623875p
+ AD=0.0798p PS=2.605u PD=0.8u
M$2641 VPWR \$I5082 \$I5075 VPWR sg13_lv_pmos L=0.13u W=1u AS=0.3623875p
+ AD=0.34p PS=2.605u PD=2.68u
M$2642 \$I5083 \$I5087 \$I5089 VPWR sg13_lv_pmos L=0.13u W=0.42u AS=0.2048p
+ AD=0.09345p PS=1.63u PD=0.865u
M$2643 \$I5089 \$I5080 VPWR VPWR sg13_lv_pmos L=0.13u W=0.42u AS=0.09345p
+ AD=0.204p PS=0.865u PD=1.835u
M$2644 VPWR \$823 \$I5080 VPWR sg13_lv_pmos L=0.13u W=0.42u AS=0.204p
+ AD=0.0798p PS=1.835u PD=0.8u
M$2645 \$I5080 \$I5083 VPWR VPWR sg13_lv_pmos L=0.13u W=0.42u AS=0.0798p
+ AD=0.4659p PS=0.8u PD=3.65u
M$2646 \$I5075 \$I5076 \$I5083 VPWR sg13_lv_pmos L=0.13u W=1u AS=0.34p
+ AD=0.2048p PS=2.68u PD=1.63u
M$2647 \$I5081 \$I5083 VPWR VPWR sg13_lv_pmos L=0.13u W=1.12u AS=0.3864p
+ AD=0.2128p PS=2.93u PD=1.5u
M$2648 VPWR \$I5081 \$825 VPWR sg13_lv_pmos L=0.13u W=1.12u AS=0.2128p
+ AD=0.3808p PS=1.5u PD=2.92u
M$2649 \$I5094 \$I5095 VGND VGND sg13_lv_nmos L=0.13u W=0.42u AS=0.1428p
+ AD=0.0798p PS=1.52u PD=0.8u
M$2650 VGND \$857 \$I5101 VGND sg13_lv_nmos L=0.13u W=0.42u AS=0.0798p
+ AD=0.0378p PS=0.8u PD=0.6u
M$2651 \$I5101 \$I5098 \$I5095 VGND sg13_lv_nmos L=0.13u W=0.42u AS=0.0378p
+ AD=0.1428p PS=0.6u PD=1.52u
M$2652 \$I5092 \$865 \$I5099 VGND sg13_lv_nmos L=0.13u W=0.42u AS=0.1428p
+ AD=0.0609p PS=1.52u PD=0.71u
M$2653 \$I5099 \$857 VGND VGND sg13_lv_nmos L=0.13u W=0.42u AS=0.0609p
+ AD=0.1626p PS=0.71u PD=1.415u
M$2654 VGND \$I5097 \$I5090 VGND sg13_lv_nmos L=0.13u W=0.74u AS=0.1626p
+ AD=0.2516p PS=1.415u PD=2.16u
M$2655 \$I5092 \$I5091 \$I5097 VGND sg13_lv_nmos L=0.13u W=0.42u AS=0.1296p
+ AD=0.0798p PS=1.52u PD=0.8u
M$2656 \$I5097 \$I5102 \$I5093 VGND sg13_lv_nmos L=0.13u W=0.42u AS=0.0798p
+ AD=0.2373p PS=0.8u PD=1.97u
M$2657 \$I5096 \$I5098 VGND VGND sg13_lv_nmos L=0.13u W=0.74u AS=0.2516p
+ AD=0.1406p PS=2.16u PD=1.12u
M$2658 VGND \$I5096 \$818 VGND sg13_lv_nmos L=0.13u W=0.74u AS=0.1406p
+ AD=0.2516p PS=1.12u PD=2.16u
M$2659 \$I5098 \$I5091 \$I5094 VGND sg13_lv_nmos L=0.13u W=0.42u AS=0.12665p
+ AD=0.1428p PS=1.145u PD=1.52u
M$2660 \$I5090 \$I5102 \$I5098 VGND sg13_lv_nmos L=0.13u W=0.74u AS=0.3473p
+ AD=0.12665p PS=2.71u PD=1.145u
M$2661 VGND \$857 \$I5100 VGND sg13_lv_nmos L=0.13u W=0.42u AS=0.1701p
+ AD=0.0378p PS=1.65u PD=0.6u
M$2662 \$I5100 \$I5090 \$I5093 VGND sg13_lv_nmos L=0.13u W=0.42u AS=0.0378p
+ AD=0.1428p PS=0.6u PD=1.52u
M$2663 VGND \$I5091 \$I5102 VGND sg13_lv_nmos L=0.13u W=0.74u AS=0.317325p
+ AD=0.2516p PS=1.805u PD=2.16u
M$2664 VGND \$587 \$I5091 VGND sg13_lv_nmos L=0.13u W=0.74u AS=0.317325p
+ AD=0.2516p PS=1.805u PD=2.16u
M$2665 \$I5097 \$857 VPWR VPWR sg13_lv_pmos L=0.13u W=0.42u AS=0.147p
+ AD=0.1563p PS=1.54u PD=1.22u
M$2666 VPWR \$I5090 \$I5103 VPWR sg13_lv_pmos L=0.13u W=0.42u AS=0.1563p
+ AD=0.063p PS=1.22u PD=0.72u
M$2667 \$I5103 \$I5091 \$I5097 VPWR sg13_lv_pmos L=0.13u W=0.42u AS=0.063p
+ AD=0.0798p PS=0.72u PD=0.8u
M$2668 \$I5097 \$I5102 \$I5092 VPWR sg13_lv_pmos L=0.13u W=0.42u AS=0.0798p
+ AD=0.1428p PS=0.8u PD=1.52u
M$2669 \$I5102 \$I5091 VPWR VPWR sg13_lv_pmos L=0.13u W=1.12u AS=0.3864p
+ AD=0.41165p PS=2.93u PD=2.12u
M$2670 VPWR \$587 \$I5091 VPWR sg13_lv_pmos L=0.13u W=1.12u AS=0.41165p
+ AD=0.4088p PS=2.12u PD=2.97u
M$2671 VPWR \$865 \$I5092 VPWR sg13_lv_pmos L=0.13u W=0.42u AS=0.1428p
+ AD=0.0798p PS=1.52u PD=0.8u
M$2672 VPWR \$857 \$I5092 VPWR sg13_lv_pmos L=0.13u W=0.42u AS=0.3623875p
+ AD=0.0798p PS=2.605u PD=0.8u
M$2673 VPWR \$I5097 \$I5090 VPWR sg13_lv_pmos L=0.13u W=1u AS=0.3623875p
+ AD=0.34p PS=2.605u PD=2.68u
M$2674 \$I5098 \$I5102 \$I5104 VPWR sg13_lv_pmos L=0.13u W=0.42u AS=0.2048p
+ AD=0.09345p PS=1.63u PD=0.865u
M$2675 \$I5104 \$I5095 VPWR VPWR sg13_lv_pmos L=0.13u W=0.42u AS=0.09345p
+ AD=0.204p PS=0.865u PD=1.835u
M$2676 VPWR \$857 \$I5095 VPWR sg13_lv_pmos L=0.13u W=0.42u AS=0.204p
+ AD=0.0798p PS=1.835u PD=0.8u
M$2677 \$I5095 \$I5098 VPWR VPWR sg13_lv_pmos L=0.13u W=0.42u AS=0.0798p
+ AD=0.4659p PS=0.8u PD=3.65u
M$2678 \$I5090 \$I5091 \$I5098 VPWR sg13_lv_pmos L=0.13u W=1u AS=0.34p
+ AD=0.2048p PS=2.68u PD=1.63u
M$2679 \$I5096 \$I5098 VPWR VPWR sg13_lv_pmos L=0.13u W=1.12u AS=0.3864p
+ AD=0.2128p PS=2.93u PD=1.5u
M$2680 VPWR \$I5096 \$818 VPWR sg13_lv_pmos L=0.13u W=1.12u AS=0.2128p
+ AD=0.3808p PS=1.5u PD=2.92u
M$2681 \$I5109 \$I5110 VGND VGND sg13_lv_nmos L=0.13u W=0.42u AS=0.1428p
+ AD=0.0798p PS=1.52u PD=0.8u
M$2682 VGND \$906 \$I5116 VGND sg13_lv_nmos L=0.13u W=0.42u AS=0.0798p
+ AD=0.0378p PS=0.8u PD=0.6u
M$2683 \$I5116 \$I5113 \$I5110 VGND sg13_lv_nmos L=0.13u W=0.42u AS=0.0378p
+ AD=0.1428p PS=0.6u PD=1.52u
M$2684 \$I5107 \$821 \$I5114 VGND sg13_lv_nmos L=0.13u W=0.42u AS=0.1428p
+ AD=0.0609p PS=1.52u PD=0.71u
M$2685 \$I5114 \$906 VGND VGND sg13_lv_nmos L=0.13u W=0.42u AS=0.0609p
+ AD=0.1626p PS=0.71u PD=1.415u
M$2686 VGND \$I5112 \$I5105 VGND sg13_lv_nmos L=0.13u W=0.74u AS=0.1626p
+ AD=0.2516p PS=1.415u PD=2.16u
M$2687 \$I5107 \$I5106 \$I5112 VGND sg13_lv_nmos L=0.13u W=0.42u AS=0.1296p
+ AD=0.0798p PS=1.52u PD=0.8u
M$2688 \$I5112 \$I5117 \$I5108 VGND sg13_lv_nmos L=0.13u W=0.42u AS=0.0798p
+ AD=0.2373p PS=0.8u PD=1.97u
M$2689 \$I5111 \$I5113 VGND VGND sg13_lv_nmos L=0.13u W=0.74u AS=0.2516p
+ AD=0.1406p PS=2.16u PD=1.12u
M$2690 VGND \$I5111 \$869 VGND sg13_lv_nmos L=0.13u W=0.74u AS=0.1406p
+ AD=0.2516p PS=1.12u PD=2.16u
M$2691 \$I5113 \$I5106 \$I5109 VGND sg13_lv_nmos L=0.13u W=0.42u AS=0.12665p
+ AD=0.1428p PS=1.145u PD=1.52u
M$2692 \$I5105 \$I5117 \$I5113 VGND sg13_lv_nmos L=0.13u W=0.74u AS=0.3473p
+ AD=0.12665p PS=2.71u PD=1.145u
M$2693 VGND \$906 \$I5115 VGND sg13_lv_nmos L=0.13u W=0.42u AS=0.1701p
+ AD=0.0378p PS=1.65u PD=0.6u
M$2694 \$I5115 \$I5105 \$I5108 VGND sg13_lv_nmos L=0.13u W=0.42u AS=0.0378p
+ AD=0.1428p PS=0.6u PD=1.52u
M$2695 VGND \$I5106 \$I5117 VGND sg13_lv_nmos L=0.13u W=0.74u AS=0.317325p
+ AD=0.2516p PS=1.805u PD=2.16u
M$2696 VGND \$608 \$I5106 VGND sg13_lv_nmos L=0.13u W=0.74u AS=0.317325p
+ AD=0.2516p PS=1.805u PD=2.16u
M$2697 \$I5112 \$906 VPWR VPWR sg13_lv_pmos L=0.13u W=0.42u AS=0.147p
+ AD=0.1563p PS=1.54u PD=1.22u
M$2698 VPWR \$I5105 \$I5118 VPWR sg13_lv_pmos L=0.13u W=0.42u AS=0.1563p
+ AD=0.063p PS=1.22u PD=0.72u
M$2699 \$I5118 \$I5106 \$I5112 VPWR sg13_lv_pmos L=0.13u W=0.42u AS=0.063p
+ AD=0.0798p PS=0.72u PD=0.8u
M$2700 \$I5112 \$I5117 \$I5107 VPWR sg13_lv_pmos L=0.13u W=0.42u AS=0.0798p
+ AD=0.1428p PS=0.8u PD=1.52u
M$2701 \$I5117 \$I5106 VPWR VPWR sg13_lv_pmos L=0.13u W=1.12u AS=0.3864p
+ AD=0.41165p PS=2.93u PD=2.12u
M$2702 VPWR \$608 \$I5106 VPWR sg13_lv_pmos L=0.13u W=1.12u AS=0.41165p
+ AD=0.4088p PS=2.12u PD=2.97u
M$2703 VPWR \$821 \$I5107 VPWR sg13_lv_pmos L=0.13u W=0.42u AS=0.1428p
+ AD=0.0798p PS=1.52u PD=0.8u
M$2704 VPWR \$906 \$I5107 VPWR sg13_lv_pmos L=0.13u W=0.42u AS=0.3623875p
+ AD=0.0798p PS=2.605u PD=0.8u
M$2705 VPWR \$I5112 \$I5105 VPWR sg13_lv_pmos L=0.13u W=1u AS=0.3623875p
+ AD=0.34p PS=2.605u PD=2.68u
M$2706 \$I5113 \$I5117 \$I5119 VPWR sg13_lv_pmos L=0.13u W=0.42u AS=0.2048p
+ AD=0.09345p PS=1.63u PD=0.865u
M$2707 \$I5119 \$I5110 VPWR VPWR sg13_lv_pmos L=0.13u W=0.42u AS=0.09345p
+ AD=0.204p PS=0.865u PD=1.835u
M$2708 VPWR \$906 \$I5110 VPWR sg13_lv_pmos L=0.13u W=0.42u AS=0.204p
+ AD=0.0798p PS=1.835u PD=0.8u
M$2709 \$I5110 \$I5113 VPWR VPWR sg13_lv_pmos L=0.13u W=0.42u AS=0.0798p
+ AD=0.4659p PS=0.8u PD=3.65u
M$2710 \$I5105 \$I5106 \$I5113 VPWR sg13_lv_pmos L=0.13u W=1u AS=0.34p
+ AD=0.2048p PS=2.68u PD=1.63u
M$2711 \$I5111 \$I5113 VPWR VPWR sg13_lv_pmos L=0.13u W=1.12u AS=0.3864p
+ AD=0.2128p PS=2.93u PD=1.5u
M$2712 VPWR \$I5111 \$869 VPWR sg13_lv_pmos L=0.13u W=1.12u AS=0.2128p
+ AD=0.3808p PS=1.5u PD=2.92u
M$2713 \$I5124 \$I5125 VGND VGND sg13_lv_nmos L=0.13u W=0.42u AS=0.1428p
+ AD=0.0798p PS=1.52u PD=0.8u
M$2714 VGND \$895 \$I5131 VGND sg13_lv_nmos L=0.13u W=0.42u AS=0.0798p
+ AD=0.0378p PS=0.8u PD=0.6u
M$2715 \$I5131 \$I5128 \$I5125 VGND sg13_lv_nmos L=0.13u W=0.42u AS=0.0378p
+ AD=0.1428p PS=0.6u PD=1.52u
M$2716 \$I5122 \$885 \$I5129 VGND sg13_lv_nmos L=0.13u W=0.42u AS=0.1428p
+ AD=0.0609p PS=1.52u PD=0.71u
M$2717 \$I5129 \$895 VGND VGND sg13_lv_nmos L=0.13u W=0.42u AS=0.0609p
+ AD=0.1626p PS=0.71u PD=1.415u
M$2718 VGND \$I5127 \$I5120 VGND sg13_lv_nmos L=0.13u W=0.74u AS=0.1626p
+ AD=0.2516p PS=1.415u PD=2.16u
M$2719 \$I5122 \$I5121 \$I5127 VGND sg13_lv_nmos L=0.13u W=0.42u AS=0.1296p
+ AD=0.0798p PS=1.52u PD=0.8u
M$2720 \$I5127 \$I5132 \$I5123 VGND sg13_lv_nmos L=0.13u W=0.42u AS=0.0798p
+ AD=0.2373p PS=0.8u PD=1.97u
M$2721 \$I5126 \$I5128 VGND VGND sg13_lv_nmos L=0.13u W=0.74u AS=0.2516p
+ AD=0.1406p PS=2.16u PD=1.12u
M$2722 VGND \$I5126 \$859 VGND sg13_lv_nmos L=0.13u W=0.74u AS=0.1406p
+ AD=0.2516p PS=1.12u PD=2.16u
M$2723 \$I5128 \$I5121 \$I5124 VGND sg13_lv_nmos L=0.13u W=0.42u AS=0.12665p
+ AD=0.1428p PS=1.145u PD=1.52u
M$2724 \$I5120 \$I5132 \$I5128 VGND sg13_lv_nmos L=0.13u W=0.74u AS=0.3473p
+ AD=0.12665p PS=2.71u PD=1.145u
M$2725 VGND \$895 \$I5130 VGND sg13_lv_nmos L=0.13u W=0.42u AS=0.1701p
+ AD=0.0378p PS=1.65u PD=0.6u
M$2726 \$I5130 \$I5120 \$I5123 VGND sg13_lv_nmos L=0.13u W=0.42u AS=0.0378p
+ AD=0.1428p PS=0.6u PD=1.52u
M$2727 VGND \$I5121 \$I5132 VGND sg13_lv_nmos L=0.13u W=0.74u AS=0.317325p
+ AD=0.2516p PS=1.805u PD=2.16u
M$2728 VGND \$587 \$I5121 VGND sg13_lv_nmos L=0.13u W=0.74u AS=0.317325p
+ AD=0.2516p PS=1.805u PD=2.16u
M$2729 \$I5127 \$895 VPWR VPWR sg13_lv_pmos L=0.13u W=0.42u AS=0.147p
+ AD=0.1563p PS=1.54u PD=1.22u
M$2730 VPWR \$I5120 \$I5133 VPWR sg13_lv_pmos L=0.13u W=0.42u AS=0.1563p
+ AD=0.063p PS=1.22u PD=0.72u
M$2731 \$I5133 \$I5121 \$I5127 VPWR sg13_lv_pmos L=0.13u W=0.42u AS=0.063p
+ AD=0.0798p PS=0.72u PD=0.8u
M$2732 \$I5127 \$I5132 \$I5122 VPWR sg13_lv_pmos L=0.13u W=0.42u AS=0.0798p
+ AD=0.1428p PS=0.8u PD=1.52u
M$2733 \$I5132 \$I5121 VPWR VPWR sg13_lv_pmos L=0.13u W=1.12u AS=0.3864p
+ AD=0.41165p PS=2.93u PD=2.12u
M$2734 VPWR \$587 \$I5121 VPWR sg13_lv_pmos L=0.13u W=1.12u AS=0.41165p
+ AD=0.4088p PS=2.12u PD=2.97u
M$2735 VPWR \$885 \$I5122 VPWR sg13_lv_pmos L=0.13u W=0.42u AS=0.1428p
+ AD=0.0798p PS=1.52u PD=0.8u
M$2736 VPWR \$895 \$I5122 VPWR sg13_lv_pmos L=0.13u W=0.42u AS=0.3623875p
+ AD=0.0798p PS=2.605u PD=0.8u
M$2737 VPWR \$I5127 \$I5120 VPWR sg13_lv_pmos L=0.13u W=1u AS=0.3623875p
+ AD=0.34p PS=2.605u PD=2.68u
M$2738 \$I5128 \$I5132 \$I5134 VPWR sg13_lv_pmos L=0.13u W=0.42u AS=0.2048p
+ AD=0.09345p PS=1.63u PD=0.865u
M$2739 \$I5134 \$I5125 VPWR VPWR sg13_lv_pmos L=0.13u W=0.42u AS=0.09345p
+ AD=0.204p PS=0.865u PD=1.835u
M$2740 VPWR \$895 \$I5125 VPWR sg13_lv_pmos L=0.13u W=0.42u AS=0.204p
+ AD=0.0798p PS=1.835u PD=0.8u
M$2741 \$I5125 \$I5128 VPWR VPWR sg13_lv_pmos L=0.13u W=0.42u AS=0.0798p
+ AD=0.4659p PS=0.8u PD=3.65u
M$2742 \$I5120 \$I5121 \$I5128 VPWR sg13_lv_pmos L=0.13u W=1u AS=0.34p
+ AD=0.2048p PS=2.68u PD=1.63u
M$2743 \$I5126 \$I5128 VPWR VPWR sg13_lv_pmos L=0.13u W=1.12u AS=0.3864p
+ AD=0.2128p PS=2.93u PD=1.5u
M$2744 VPWR \$I5126 \$859 VPWR sg13_lv_pmos L=0.13u W=1.12u AS=0.2128p
+ AD=0.3808p PS=1.5u PD=2.92u
.ENDS sar_logic

.SUBCKT cdac B4 B3 B2 B1 B0 B5 vref B8 B7 B6 B11 B10 B9 Vout
C$1 \$15 B4 cap_cmim w=10.44u l=10.44u A=108.9936p P=41.76u m=16
C$17 \$15 B3 cap_cmim w=10.44u l=10.44u A=108.9936p P=41.76u m=8
C$25 \$15 B2 cap_cmim w=10.44u l=10.44u A=108.9936p P=41.76u m=4
C$29 \$15 B1 cap_cmim w=10.44u l=10.44u A=108.9936p P=41.76u m=2
C$31 \$15 B0 cap_cmim w=10.44u l=10.44u A=108.9936p P=41.76u m=1
C$32 \$15 B5 cap_cmim w=10.44u l=10.44u A=108.9936p P=41.76u m=32
C$64 \$15 vref cap_cmim w=10.44u l=10.44u A=108.9936p P=41.76u m=1
C$65 Vout B8 cap_cmim w=10.44u l=10.44u A=108.9936p P=41.76u m=4
C$69 Vout B7 cap_cmim w=10.44u l=10.44u A=108.9936p P=41.76u m=2
C$71 Vout B6 cap_cmim w=10.44u l=10.44u A=108.9936p P=41.76u m=1
C$72 Vout B11 cap_cmim w=10.44u l=10.44u A=108.9936p P=41.76u m=32
C$104 Vout B10 cap_cmim w=10.44u l=10.44u A=108.9936p P=41.76u m=16
C$120 Vout B9 cap_cmim w=10.44u l=10.44u A=108.9936p P=41.76u m=8
C$128 Vout \$15 cap_cmim w=10.44u l=10.44u A=108.9936p P=41.76u m=1
.ENDS cdac

.SUBCKT cdac$2 B4 B3 B2 B1 B0 B5 vref B8 B7 B6 B11 B10 B9 Vout
C$1 \$15 B4 cap_cmim w=10.44u l=10.44u A=108.9936p P=41.76u m=16
C$17 \$15 B3 cap_cmim w=10.44u l=10.44u A=108.9936p P=41.76u m=8
C$25 \$15 B2 cap_cmim w=10.44u l=10.44u A=108.9936p P=41.76u m=4
C$29 \$15 B1 cap_cmim w=10.44u l=10.44u A=108.9936p P=41.76u m=2
C$31 \$15 B0 cap_cmim w=10.44u l=10.44u A=108.9936p P=41.76u m=1
C$32 \$15 B5 cap_cmim w=10.44u l=10.44u A=108.9936p P=41.76u m=32
C$64 \$15 vref cap_cmim w=10.44u l=10.44u A=108.9936p P=41.76u m=1
C$65 Vout B8 cap_cmim w=10.44u l=10.44u A=108.9936p P=41.76u m=4
C$69 Vout B7 cap_cmim w=10.44u l=10.44u A=108.9936p P=41.76u m=2
C$71 Vout B6 cap_cmim w=10.44u l=10.44u A=108.9936p P=41.76u m=1
C$72 Vout B11 cap_cmim w=10.44u l=10.44u A=108.9936p P=41.76u m=32
C$104 Vout B10 cap_cmim w=10.44u l=10.44u A=108.9936p P=41.76u m=16
C$120 Vout B9 cap_cmim w=10.44u l=10.44u A=108.9936p P=41.76u m=8
C$128 Vout \$15 cap_cmim w=10.44u l=10.44u A=108.9936p P=41.76u m=1
.ENDS cdac$2

.SUBCKT switch_array_new$2 D5 D4 D3 D2 D1 D0 gnd Vref S5 S4 S3 S2 S1 S0 vdd
+ D_MSB D10 D9 D8 D7 D6 S_MSB S10 S9 S8 S7 S6
M$1 Vref D5 S5 gnd sg13_lv_nmos L=0.13u W=2u AS=0.68p AD=0.68p PS=4.68u PD=4.68u
M$2 Vref D4 S4 gnd sg13_lv_nmos L=0.13u W=2u AS=0.68p AD=0.68p PS=4.68u PD=4.68u
M$3 Vref D3 S3 gnd sg13_lv_nmos L=0.13u W=2u AS=0.68p AD=0.68p PS=4.68u PD=4.68u
M$4 Vref D2 S2 gnd sg13_lv_nmos L=0.13u W=2u AS=0.68p AD=0.68p PS=4.68u PD=4.68u
M$5 Vref D1 S1 gnd sg13_lv_nmos L=0.13u W=2u AS=0.68p AD=0.68p PS=4.68u PD=4.68u
M$6 Vref D0 S0 gnd sg13_lv_nmos L=0.13u W=2u AS=0.68p AD=0.68p PS=4.68u PD=4.68u
M$7 gnd \$110 S7 gnd sg13_lv_nmos L=0.13u W=2u AS=0.68p AD=0.68p PS=4.68u
+ PD=4.68u
M$8 gnd \$109 S8 gnd sg13_lv_nmos L=0.13u W=2u AS=0.68p AD=0.68p PS=4.68u
+ PD=4.68u
M$9 gnd \$108 S9 gnd sg13_lv_nmos L=0.13u W=2u AS=0.68p AD=0.68p PS=4.68u
+ PD=4.68u
M$10 gnd \$111 S6 gnd sg13_lv_nmos L=0.13u W=2u AS=0.68p AD=0.68p PS=4.68u
+ PD=4.68u
M$11 gnd \$25 S2 gnd sg13_lv_nmos L=0.13u W=2u AS=0.68p AD=0.68p PS=4.68u
+ PD=4.68u
M$12 gnd \$23 S4 gnd sg13_lv_nmos L=0.13u W=2u AS=0.68p AD=0.68p PS=4.68u
+ PD=4.68u
M$13 gnd \$21 S5 gnd sg13_lv_nmos L=0.13u W=2u AS=0.68p AD=0.68p PS=4.68u
+ PD=4.68u
M$14 gnd \$24 S3 gnd sg13_lv_nmos L=0.13u W=2u AS=0.68p AD=0.68p PS=4.68u
+ PD=4.68u
M$15 gnd \$106 S_MSB gnd sg13_lv_nmos L=0.13u W=2u AS=0.68p AD=0.68p PS=4.68u
+ PD=4.68u
M$16 gnd \$26 S1 gnd sg13_lv_nmos L=0.13u W=2u AS=0.68p AD=0.68p PS=4.68u
+ PD=4.68u
M$17 gnd \$107 S10 gnd sg13_lv_nmos L=0.13u W=2u AS=0.68p AD=0.68p PS=4.68u
+ PD=4.68u
M$18 gnd \$27 S0 gnd sg13_lv_nmos L=0.13u W=2u AS=0.68p AD=0.68p PS=4.68u
+ PD=4.68u
M$19 Vref D6 S6 gnd sg13_lv_nmos L=0.13u W=2u AS=0.68p AD=0.68p PS=4.68u
+ PD=4.68u
M$20 Vref D7 S7 gnd sg13_lv_nmos L=0.13u W=2u AS=0.68p AD=0.68p PS=4.68u
+ PD=4.68u
M$21 Vref D8 S8 gnd sg13_lv_nmos L=0.13u W=2u AS=0.68p AD=0.68p PS=4.68u
+ PD=4.68u
M$22 Vref D9 S9 gnd sg13_lv_nmos L=0.13u W=2u AS=0.68p AD=0.68p PS=4.68u
+ PD=4.68u
M$23 Vref D10 S10 gnd sg13_lv_nmos L=0.13u W=2u AS=0.68p AD=0.68p PS=4.68u
+ PD=4.68u
M$24 Vref D_MSB S_MSB gnd sg13_lv_nmos L=0.13u W=2u AS=0.68p AD=0.68p PS=4.68u
+ PD=4.68u
M$25 gnd D5 S5 vdd sg13_lv_pmos L=0.13u W=4u AS=1.36p AD=1.36p PS=8.68u PD=8.68u
M$26 gnd D4 S4 vdd sg13_lv_pmos L=0.13u W=4u AS=1.36p AD=1.36p PS=8.68u PD=8.68u
M$27 gnd D3 S3 vdd sg13_lv_pmos L=0.13u W=4u AS=1.36p AD=1.36p PS=8.68u PD=8.68u
M$28 gnd D2 S2 vdd sg13_lv_pmos L=0.13u W=4u AS=1.36p AD=1.36p PS=8.68u PD=8.68u
M$29 gnd D1 S1 vdd sg13_lv_pmos L=0.13u W=4u AS=1.36p AD=1.36p PS=8.68u PD=8.68u
M$30 gnd D0 S0 vdd sg13_lv_pmos L=0.13u W=4u AS=1.36p AD=1.36p PS=8.68u PD=8.68u
M$31 gnd D7 S7 vdd sg13_lv_pmos L=0.13u W=4u AS=1.36p AD=1.36p PS=8.68u PD=8.68u
M$32 gnd D8 S8 vdd sg13_lv_pmos L=0.13u W=4u AS=1.36p AD=1.36p PS=8.68u PD=8.68u
M$33 gnd D6 S6 vdd sg13_lv_pmos L=0.13u W=4u AS=1.36p AD=1.36p PS=8.68u PD=8.68u
M$34 gnd D9 S9 vdd sg13_lv_pmos L=0.13u W=4u AS=1.36p AD=1.36p PS=8.68u PD=8.68u
M$35 gnd D10 S10 vdd sg13_lv_pmos L=0.13u W=4u AS=1.36p AD=1.36p PS=8.68u
+ PD=8.68u
M$36 gnd D_MSB S_MSB vdd sg13_lv_pmos L=0.13u W=4u AS=1.36p AD=1.36p PS=8.68u
+ PD=8.68u
M$37 Vref \$21 S5 vdd sg13_lv_pmos L=0.13u W=4u AS=1.36p AD=1.36p PS=8.68u
+ PD=8.68u
M$38 Vref \$24 S3 vdd sg13_lv_pmos L=0.13u W=4u AS=1.36p AD=1.36p PS=8.68u
+ PD=8.68u
M$39 Vref \$26 S1 vdd sg13_lv_pmos L=0.13u W=4u AS=1.36p AD=1.36p PS=8.68u
+ PD=8.68u
M$40 Vref \$27 S0 vdd sg13_lv_pmos L=0.13u W=4u AS=1.36p AD=1.36p PS=8.68u
+ PD=8.68u
M$41 Vref \$110 S7 vdd sg13_lv_pmos L=0.13u W=4u AS=1.36p AD=1.36p PS=8.68u
+ PD=8.68u
M$42 Vref \$107 S10 vdd sg13_lv_pmos L=0.13u W=4u AS=1.36p AD=1.36p PS=8.68u
+ PD=8.68u
M$43 Vref \$106 S_MSB vdd sg13_lv_pmos L=0.13u W=4u AS=1.36p AD=1.36p PS=8.68u
+ PD=8.68u
M$44 Vref \$108 S9 vdd sg13_lv_pmos L=0.13u W=4u AS=1.36p AD=1.36p PS=8.68u
+ PD=8.68u
M$45 Vref \$109 S8 vdd sg13_lv_pmos L=0.13u W=4u AS=1.36p AD=1.36p PS=8.68u
+ PD=8.68u
M$46 Vref \$111 S6 vdd sg13_lv_pmos L=0.13u W=4u AS=1.36p AD=1.36p PS=8.68u
+ PD=8.68u
M$47 Vref \$25 S2 vdd sg13_lv_pmos L=0.13u W=4u AS=1.36p AD=1.36p PS=8.68u
+ PD=8.68u
M$48 Vref \$23 S4 vdd sg13_lv_pmos L=0.13u W=4u AS=1.36p AD=1.36p PS=8.68u
+ PD=8.68u
M$49 gnd D5 \$21 gnd sg13_lv_nmos L=0.13u W=0.4u AS=0.136p AD=0.136p PS=1.48u
+ PD=1.48u
M$50 gnd D4 \$23 gnd sg13_lv_nmos L=0.13u W=0.4u AS=0.136p AD=0.136p PS=1.48u
+ PD=1.48u
M$51 gnd D3 \$24 gnd sg13_lv_nmos L=0.13u W=0.4u AS=0.136p AD=0.136p PS=1.48u
+ PD=1.48u
M$52 gnd D2 \$25 gnd sg13_lv_nmos L=0.13u W=0.4u AS=0.136p AD=0.136p PS=1.48u
+ PD=1.48u
M$53 gnd D1 \$26 gnd sg13_lv_nmos L=0.13u W=0.4u AS=0.136p AD=0.136p PS=1.48u
+ PD=1.48u
M$54 gnd D0 \$27 gnd sg13_lv_nmos L=0.13u W=0.4u AS=0.136p AD=0.136p PS=1.48u
+ PD=1.48u
M$55 gnd D6 \$111 gnd sg13_lv_nmos L=0.13u W=0.4u AS=0.136p AD=0.136p PS=1.48u
+ PD=1.48u
M$56 gnd D9 \$108 gnd sg13_lv_nmos L=0.13u W=0.4u AS=0.136p AD=0.136p PS=1.48u
+ PD=1.48u
M$57 gnd D7 \$110 gnd sg13_lv_nmos L=0.13u W=0.4u AS=0.136p AD=0.136p PS=1.48u
+ PD=1.48u
M$58 gnd D_MSB \$106 gnd sg13_lv_nmos L=0.13u W=0.4u AS=0.136p AD=0.136p
+ PS=1.48u PD=1.48u
M$59 gnd D10 \$107 gnd sg13_lv_nmos L=0.13u W=0.4u AS=0.136p AD=0.136p PS=1.48u
+ PD=1.48u
M$60 gnd D8 \$109 gnd sg13_lv_nmos L=0.13u W=0.4u AS=0.136p AD=0.136p PS=1.48u
+ PD=1.48u
M$61 vdd D5 \$21 vdd sg13_lv_pmos L=0.13u W=0.8u AS=0.272p AD=0.272p PS=2.28u
+ PD=2.28u
M$62 vdd D4 \$23 vdd sg13_lv_pmos L=0.13u W=0.8u AS=0.272p AD=0.272p PS=2.28u
+ PD=2.28u
M$63 vdd D3 \$24 vdd sg13_lv_pmos L=0.13u W=0.8u AS=0.272p AD=0.272p PS=2.28u
+ PD=2.28u
M$64 vdd D2 \$25 vdd sg13_lv_pmos L=0.13u W=0.8u AS=0.272p AD=0.272p PS=2.28u
+ PD=2.28u
M$65 vdd D1 \$26 vdd sg13_lv_pmos L=0.13u W=0.8u AS=0.272p AD=0.272p PS=2.28u
+ PD=2.28u
M$66 vdd D0 \$27 vdd sg13_lv_pmos L=0.13u W=0.8u AS=0.272p AD=0.272p PS=2.28u
+ PD=2.28u
M$67 vdd D6 \$111 vdd sg13_lv_pmos L=0.13u W=0.8u AS=0.272p AD=0.272p PS=2.28u
+ PD=2.28u
M$68 vdd D7 \$110 vdd sg13_lv_pmos L=0.13u W=0.8u AS=0.272p AD=0.272p PS=2.28u
+ PD=2.28u
M$69 vdd D8 \$109 vdd sg13_lv_pmos L=0.13u W=0.8u AS=0.272p AD=0.272p PS=2.28u
+ PD=2.28u
M$70 vdd D9 \$108 vdd sg13_lv_pmos L=0.13u W=0.8u AS=0.272p AD=0.272p PS=2.28u
+ PD=2.28u
M$71 vdd D10 \$107 vdd sg13_lv_pmos L=0.13u W=0.8u AS=0.272p AD=0.272p PS=2.28u
+ PD=2.28u
M$72 vdd D_MSB \$106 vdd sg13_lv_pmos L=0.13u W=0.8u AS=0.272p AD=0.272p
+ PS=2.28u PD=2.28u
.ENDS switch_array_new$2
